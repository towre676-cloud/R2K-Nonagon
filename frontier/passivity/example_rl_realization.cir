* Exact decimal-rational passive realization; s=+i*2*pi*f_hz
.subckt NONAGON_POSITIVE_REAL portp portn
R0_0 portp n1 {1/10}
L1_0 n1 n2 {1/1000}
C2_0 n2 n3 1000
R3_0 n3 n4 1
C3_1 n3 n4 1
R4_0 n4 portn {3/5}
L4_1 n4 portn {3/500}
.ends NONAGON_POSITIVE_REAL
