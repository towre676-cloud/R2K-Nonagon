* Exact decimal-rational passive realization; s=+i*2*pi*f_hz
.subckt NONAGON_POSITIVE_REAL portp portn
R0_0 portp n1 {13869926350155977/1000000000000000000}
L1_0 n1 n2 {9378475213561277/100000000000000000000000}
R2_0 n2 n3 {1566533883082867/1000000000000000000}
C2_1 n2 n3 {2735023091892717/15665338830828670}
R3_0 n3 n4 {1213954083946077/1000000000000000000}
C3_1 n3 n4 {6939906281779079/12139540839460770}
R4_0 n4 n5 {9056079960751233/10000000000000000000}
C4_1 n4 n5 {17609467116618380/9056079960751233}
R5_0 n5 n6 {272626054193007/625000000000000000}
C5_1 n5 n6 {22341319863743875/2181008433544056}
R6_0 n6 n7 {5510031989690811/1000000000000000000000}
C6_1 n6 n7 {11337868884926657000/5510031989690811}
R7_0 n7 n8 {7039845712531323/50000000000000000000}
C7_1 n7 n8 {53275836662564600/260735026390049}
R8_0 n8 n9 {127842937413263/2000000000000000000}
C8_1 n8 n9 {145997911237729460/127842937413263}
R9_0 n9 n10 {21808504976050317/100000000000000000000}
C9_1 n9 n10 {18522911640650383000/21808504976050317}
R10_0 n10 n11 {704290389662253/3125000000000000000}
C10_1 n10 n11 {979175697157381875/469526926441502}
R11_0 n11 n12 {7012761709722367/10000000000000000000}
C11_1 n11 n12 {11925990841062142000/7012761709722367}
R12_0 n12 n13 {17474242107919627/5000000000000000000}
C12_1 n12 n13 {38392791668066385000/17474242107919627}
R13_0 n13 portn {1377679088091209/500000000000000000}
C13_1 n13 portn {512729965342505000/72509425689011}
.ends NONAGON_POSITIVE_REAL
