* Exact decimal-rational passive realization; s=+i*2*pi*f_hz
.subckt NONAGON_POSITIVE_REAL portp portn
R0_0 portp n1 {14052778566154837/1000000000000000000}
L1_0 n1 n2 {9420383822836729/100000000000000000000000}
R2_0 n2 n3 {8117579903542271/5000000000000000000}
C2_1 n2 n3 {2735023091892717/16235159807084542}
R3_0 n3 n4 {3080172085057057/2500000000000000000}
C3_1 n3 n4 {6939906281779079/12320688340228228}
R4_0 n4 n5 {426113389598449/400000000000000000}
C4_1 n4 n5 {3521893423323676/2130566947992245}
R5_0 n5 n6 {909509479012517/2500000000000000000}
C5_1 n5 n6 {22341319863743875/1819018958025034}
R6_0 n6 n7 {1848249326678233/20000000000000000000}
C6_1 n6 n7 {226757377698533140/1848249326678233}
R7_0 n7 n8 {9832893918091579/100000000000000000000}
C7_1 n7 n8 {2876895179778488400/9832893918091579}
R8_0 n8 n9 {2188258076575537/25000000000000000000}
C8_1 n8 n9 {1824973890471618250/2188258076575537}
R9_0 n9 n10 {16780431478156883/100000000000000000000}
C9_1 n9 n10 {18522911640650383000/16780431478156883}
R10_0 n10 n11 {3083759759391339/10000000000000000000}
C10_1 n10 n11 {1566681115451811000/1027919919797113}
R11_0 n11 n12 {6022710369958599/10000000000000000000}
C11_1 n11 n12 {11925990841062142000/6022710369958599}
R12_0 n12 n13 {35888870343993677/10000000000000000000}
C12_1 n12 n13 {76785583336132770000/35888870343993677}
R13_0 n13 portn {1380694299447513/500000000000000000}
C13_1 n13 portn {9741869341507595000/1380694299447513}
.ends NONAGON_POSITIVE_REAL
