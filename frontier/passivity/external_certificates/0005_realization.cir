* Exact decimal-rational passive realization; s=+i*2*pi*f_hz
.subckt NONAGON_POSITIVE_REAL portp portn
R0_0 portp n1 {14016792287738333/1000000000000000000}
L1_0 n1 n2 {2366156246874139/25000000000000000000000}
R2_0 n2 n3 {17380235082696377/10000000000000000000}
C2_1 n2 n3 {2735023091892717/17380235082696377}
R3_0 n3 n4 {545953660878023/500000000000000000}
C3_1 n3 n4 {6939906281779079/10919073217560460}
R4_0 n4 n5 {71165458776699/62500000000000000}
C4_1 n4 n5 {880473355830919/569323670213592}
R5_0 n5 n6 {36909494194607717/100000000000000000000}
C5_1 n5 n6 {446826397274877500/36909494194607717}
R6_0 n6 n7 {163619678207269/2500000000000000000}
C6_1 n6 n7 {56689344424633285/327239356414538}
R7_0 n7 n8 {10566114120074457/100000000000000000000}
C7_1 n7 n8 {45665002853626800/167716097144039}
R8_0 n8 n9 {142381190461321/1562500000000000000}
C8_1 n8 n9 {130355277890829875/162721360527224}
R9_0 n9 n10 {19118098303083983/100000000000000000000}
C9_1 n9 n10 {18522911640650383000/19118098303083983}
R10_0 n10 n11 {300345676337237/1250000000000000000}
C10_1 n10 n11 {587505418294429125/300345676337237}
R11_0 n11 n12 {3471035000724449/5000000000000000000}
C11_1 n11 n12 {5962995420531071000/3471035000724449}
R12_0 n12 n13 {32587735233740047/10000000000000000000}
C12_1 n12 n13 {76785583336132770000/32587735233740047}
R13_0 n13 portn {1669077123533381/500000000000000000}
C13_1 n13 portn {9741869341507595000/1669077123533381}
.ends NONAGON_POSITIVE_REAL
