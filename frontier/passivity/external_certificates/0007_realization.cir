* Exact decimal-rational passive realization; s=+i*2*pi*f_hz
.subckt NONAGON_POSITIVE_REAL portp portn
R0_0 portp n1 {13991069890058683/1000000000000000000}
L1_0 n1 n2 {9485446429556953/100000000000000000000000}
R2_0 n2 n3 {181728431096409/100000000000000000}
C2_1 n2 n3 {911674363964239/6057614369880300}
R3_0 n3 n4 {945659023861949/1000000000000000000}
C3_1 n3 n4 {6939906281779079/9456590238619490}
R4_0 n4 n5 {12983180554162511/10000000000000000000}
C4_1 n4 n5 {17609467116618380/12983180554162511}
R5_0 n5 n6 {817064845826391/2000000000000000000}
C5_1 n5 n6 {8936527945497550/817064845826391}
R6_0 n6 n7 {2061140579507949/100000000000000000000}
C6_1 n6 n7 {958965059926162800/687046859835983}
R7_0 n7 n8 {4633167052501629/25000000000000000000}
C7_1 n7 n8 {1824973890471618250/4633167052501629}
R8_0 n8 n9 {2192145000969139/20000000000000000000}
C8_1 n8 n9 {3704582328130076600/2192145000969139}
R9_0 n9 n10 {590215275456981/2000000000000000000}
C9_1 n9 n10 {313336223090362200/196738425152327}
R10_0 n10 n11 {678452459568453/1000000000000000000}
C10_1 n10 n11 {1192599084106214200/678452459568453}
R11_0 n11 n12 {31529890435491913/10000000000000000000}
C11_1 n11 n12 {76785583336132770000/31529890435491913}
R12_0 n12 portn {17891654007940697/5000000000000000000}
C12_1 n12 portn {97418693415075950000/17891654007940697}
.ends NONAGON_POSITIVE_REAL
