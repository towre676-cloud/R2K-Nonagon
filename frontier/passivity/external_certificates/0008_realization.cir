* Exact decimal-rational passive realization; s=+i*2*pi*f_hz
.subckt NONAGON_POSITIVE_REAL portp portn
R0_0 portp n1 {3421681037968661/250000000000000000}
L1_0 n1 n2 {9125661974707169/100000000000000000000000}
R2_0 n2 n3 {2129112328461777/1250000000000000000}
C2_1 n2 n3 {911674363964239/5677632875898072}
R3_0 n3 n4 {2395671250407147/2000000000000000000}
C3_1 n3 n4 {6939906281779079/11978356252035735}
R4_0 n4 n5 {2283034577984267/2000000000000000000}
C4_1 n4 n5 {3521893423323676/2283034577984267}
R5_0 n5 n6 {36533059867129133/100000000000000000000}
C5_1 n5 n6 {446826397274877500/36533059867129133}
R6_0 n6 n7 {1322935042445103/12500000000000000000}
C6_1 n6 n7 {283446722123166425/2645870084890206}
R7_0 n7 n8 {8042090106984769/100000000000000000000}
C7_1 n7 n8 {2876895179778488400/8042090106984769}
R8_0 n8 n9 {10799780388703187/100000000000000000000}
C8_1 n8 n9 {1042842223126639000/1542825769814741}
R9_0 n9 n10 {281014590402501/1562500000000000000}
C9_1 n9 n10 {2315363955081297875/2248116723220008}
R10_0 n10 n11 {131293735711619/500000000000000000}
C10_1 n10 n11 {235002167317771650/131293735711619}
R11_0 n11 n12 {6789968730083357/10000000000000000000}
C11_1 n11 n12 {917383910850934000/522305286929489}
R12_0 n12 n13 {378235465179173/125000000000000000}
C12_1 n12 n13 {959819791701659625/378235465179173}
R13_0 n13 portn {497852253601853/125000000000000000}
C13_1 n13 portn {2435467335376898750/497852253601853}
.ends NONAGON_POSITIVE_REAL
