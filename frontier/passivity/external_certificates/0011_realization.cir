* Exact decimal-rational passive realization; s=+i*2*pi*f_hz
.subckt NONAGON_POSITIVE_REAL portp portn
R0_0 portp n1 {13625533794069493/1000000000000000000}
L1_0 n1 n2 {918096202293899/10000000000000000000000}
R2_0 n2 n3 {9531291151675663/5000000000000000000}
C2_1 n2 n3 {2735023091892717/19062582303351326}
R3_0 n3 n4 {8849790194901119/10000000000000000000}
C3_1 n3 n4 {6939906281779079/8849790194901119}
R4_0 n4 n5 {704293769088103/500000000000000000}
C4_1 n4 n5 {880473355830919/704293769088103}
R5_0 n5 n6 {378297674624801/1000000000000000000}
C5_1 n5 n6 {4468263972748775/378297674624801}
R6_0 n6 n7 {5219536139923991/100000000000000000000}
C6_1 n6 n7 {2876895179778488400/5219536139923991}
R7_0 n7 n8 {17651472419676103/100000000000000000000}
C7_1 n7 n8 {7299895561886473000/17651472419676103}
R8_0 n8 n9 {10657689657806161/100000000000000000000}
C8_1 n8 n9 {18522911640650383000/10657689657806161}
R9_0 n9 n10 {2046682562004991/6250000000000000000}
C9_1 n9 n10 {2937527091472145625/2046682562004991}
R10_0 n10 n11 {5890895331450241/10000000000000000000}
C10_1 n10 n11 {11925990841062142000/5890895331450241}
R11_0 n11 n12 {27777871396081463/100000000000000000000}
C11_1 n11 n12 {302612650692652840000/27777871396081463}
R12_0 n12 n13 {21369526122390187/10000000000000000000}
C12_1 n12 n13 {76785583336132770000/21369526122390187}
R13_0 n13 portn {5232803219721703/1000000000000000000}
C13_1 n13 portn {19483738683015190000/5232803219721703}
.ends NONAGON_POSITIVE_REAL
