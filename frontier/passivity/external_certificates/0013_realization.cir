* Exact decimal-rational passive realization; s=+i*2*pi*f_hz
.subckt NONAGON_POSITIVE_REAL portp portn
R0_0 portp n1 {13527793975313333/1000000000000000000}
L1_0 n1 n2 {9075758235307837/100000000000000000000000}
R2_0 n2 n3 {3811763910035563/2000000000000000000}
C2_1 n2 n3 {2735023091892717/19058819550177815}
R3_0 n3 n4 {2380182003611453/2500000000000000000}
C3_1 n3 n4 {6939906281779079/9520728014445812}
R4_0 n4 n5 {3482734919853/2500000000000000}
C4_1 n4 n5 {880473355830919/696546983970600}
R5_0 n5 n6 {7265428198859499/25000000000000000000}
C5_1 n5 n6 {111706599318719375/7265428198859499}
R6_0 n6 n7 {2014885919383391/10000000000000000000}
C6_1 n6 n7 {113378688849266570/2014885919383391}
R7_0 n7 n8 {4663250107082397/200000000000000000000}
C7_1 n7 n8 {639310039950775200/518138900786933}
R8_0 n8 n9 {1674952862196431/10000000000000000000}
C8_1 n8 n9 {729989556188647300/1674952862196431}
R9_0 n9 n10 {16510978634052723/100000000000000000000}
C9_1 n9 n10 {18522911640650383000/16510978634052723}
R10_0 n10 n11 {336268871472603/1250000000000000000}
C10_1 n10 n11 {195835139431476375/112089623824201}
R11_0 n11 n12 {1234316323122819/2000000000000000000}
C11_1 n11 n12 {2385198168212428400/1234316323122819}
R12_0 n12 n13 {2631279122532049/6250000000000000000}
C12_1 n12 n13 {18913290668290802500/2631279122532049}
R13_0 n13 n14 {1529426985170897/2000000000000000000}
C13_1 n13 n14 {15357116667226554000/1529426985170897}
R14_0 n14 portn {3906420551490661/500000000000000000}
C14_1 n14 portn {9741869341507595000/3906420551490661}
.ends NONAGON_POSITIVE_REAL
