* Exact decimal-rational passive realization; s=+i*2*pi*f_hz
.subckt NONAGON_POSITIVE_REAL portp portn
R0_0 portp n1 {6764882614087887/500000000000000000}
L1_0 n1 n2 {9053242520733361/100000000000000000000000}
R2_0 n2 n3 {3847091440150283/2000000000000000000}
C2_1 n2 n3 {2735023091892717/19235457200751415}
R3_0 n3 n4 {2069632298456917/2500000000000000000}
C3_1 n3 n4 {6939906281779079/8278529193827668}
R4_0 n4 n5 {1577485011734179/1000000000000000000}
C4_1 n4 n5 {1760946711661838/1577485011734179}
R5_0 n5 n6 {264717054321823/625000000000000000}
C5_1 n5 n6 {720687737540125/68314078534664}
R6_0 n6 n7 {2601640326871679/12500000000000000000}
C6_1 n6 n7 {912486945235809125/2601640326871679}
R7_0 n7 n8 {1725921601293403/12500000000000000000}
C7_1 n7 n8 {2315363955081297875/1725921601293403}
R8_0 n8 n9 {3146289355201533/12500000000000000000}
C8_1 n8 n9 {1958351394314763750/1048763118400511}
R9_0 n9 n10 {860337608189501/1250000000000000000}
C9_1 n9 n10 {114672988856366750/66179816014577}
R10_0 n10 n11 {925566114134441/4000000000000000000}
C10_1 n10 n11 {12104506027706113600/925566114134441}
R11_0 n11 n12 {734433141053807/625000000000000000}
C11_1 n11 n12 {4799098958508298125/734433141053807}
R12_0 n12 portn {461567503956061/62500000000000000}
C12_1 n12 portn {1217733667688449375/461567503956061}
.ends NONAGON_POSITIVE_REAL
