* Exact decimal-rational passive realization; s=+i*2*pi*f_hz
.subckt NONAGON_POSITIVE_REAL portp portn
R0_0 portp n1 {134843598532439/10000000000000000}
L1_0 n1 n2 {9319530072486761/100000000000000000000000}
R2_0 n2 n3 {9810579411394613/5000000000000000000}
C2_1 n2 n3 {2735023091892717/19621158822789226}
R3_0 n3 n4 {195359087164779/250000000000000000}
C3_1 n3 n4 {6939906281779079/7814363486591160}
R4_0 n4 n5 {116639553383691/80000000000000000}
C4_1 n4 n5 {3521893423323676/2915988834592275}
R5_0 n5 n6 {40906866483433223/100000000000000000000}
C5_1 n5 n6 {446826397274877500/40906866483433223}
R6_0 n6 n7 {17125355050590663/1000000000000000000000}
C6_1 n6 n7 {3196550199753876000/1902817227843407}
R7_0 n7 n8 {20799722155741501/100000000000000000000}
C7_1 n7 n8 {1042842223126639000/2971388879391643}
R8_0 n8 n9 {4338518537762083/50000000000000000000}
C8_1 n8 n9 {9261455820325191500/4338518537762083}
R9_0 n9 n10 {3031100656377129/10000000000000000000}
C9_1 n9 n10 {522227038483937000/336788961819681}
R10_0 n10 n11 {3411636043227609/5000000000000000000}
C10_1 n10 n11 {5962995420531071000/3411636043227609}
R11_0 n11 n12 {30196515857735013/10000000000000000000}
C11_1 n11 n12 {25595194445377590000/10065505285911671}
R12_0 n12 portn {38933839131710473/10000000000000000000}
C12_1 n12 portn {194837386830151900000/38933839131710473}
.ends NONAGON_POSITIVE_REAL
