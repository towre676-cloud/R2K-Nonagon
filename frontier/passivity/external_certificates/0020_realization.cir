* Exact decimal-rational passive realization; s=+i*2*pi*f_hz
.subckt NONAGON_POSITIVE_REAL portp portn
R0_0 portp n1 {13624972133729181/1000000000000000000}
L1_0 n1 n2 {2298268438287527/25000000000000000000000}
R2_0 n2 n3 {17778917679191729/10000000000000000000}
C2_1 n2 n3 {2735023091892717/17778917679191729}
R3_0 n3 n4 {2931037004095477/2500000000000000000}
C3_1 n3 n4 {6939906281779079/11724148016381908}
R4_0 n4 n5 {12607729794585731/10000000000000000000}
C4_1 n4 n5 {17609467116618380/12607729794585731}
R5_0 n5 n6 {704896134922301/2000000000000000000}
C5_1 n5 n6 {8936527945497550/704896134922301}
R6_0 n6 n7 {7490435251174401/50000000000000000000}
C6_1 n6 n7 {566893444246332850/7490435251174401}
R7_0 n7 n8 {6625298042522941/100000000000000000000}
C7_1 n7 n8 {2876895179778488400/6625298042522941}
R8_0 n8 n9 {3542176042422119/25000000000000000000}
C8_1 n8 n9 {1824973890471618250/3542176042422119}
R9_0 n9 n10 {11087912700299/78125000000000000}
C9_1 n9 n10 {463072791016259575/354813206409568}
R10_0 n10 n11 {15474150715590873/50000000000000000000}
C10_1 n10 n11 {2611135192419685000/1719350079510097}
R11_0 n11 n12 {3247039654327329/5000000000000000000}
C11_1 n11 n12 {5962995420531071000/3247039654327329}
R12_0 n12 n13 {28746155967053423/10000000000000000000}
C12_1 n12 n13 {76785583336132770000/28746155967053423}
R13_0 n13 portn {2206562041984891/500000000000000000}
C13_1 n13 portn {9741869341507595000/2206562041984891}
.ends NONAGON_POSITIVE_REAL
