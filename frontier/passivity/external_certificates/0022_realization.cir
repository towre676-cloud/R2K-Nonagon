* Exact decimal-rational passive realization; s=+i*2*pi*f_hz
.subckt NONAGON_POSITIVE_REAL portp portn
R0_0 portp n1 {3397481439105799/250000000000000000}
L1_0 n1 n2 {9202500338115079/100000000000000000000000}
R2_0 n2 n3 {9737044802517053/5000000000000000000}
C2_1 n2 n3 {2735023091892717/19474089605034106}
R3_0 n3 n4 {2025970317967903/2500000000000000000}
C3_1 n3 n4 {6939906281779079/8103881271871612}
R4_0 n4 n5 {17151830436534443/10000000000000000000}
C4_1 n4 n5 {17609467116618380/17151830436534443}
R5_0 n5 n6 {2921913998855189/10000000000000000000}
C5_1 n5 n6 {44682639727487750/2921913998855189}
R6_0 n6 n7 {12609856482987097/50000000000000000000}
C6_1 n6 n7 {3649947780943236500/12609856482987097}
R7_0 n7 n8 {5983260643681629/100000000000000000000}
C7_1 n7 n8 {18522911640650383000/5983260643681629}
R8_0 n8 n9 {167391093869711/500000000000000000}
C8_1 n8 n9 {235002167317771650/167391093869711}
R9_0 n9 n10 {6510391836811871/10000000000000000000}
C9_1 n9 n10 {11925990841062142000/6510391836811871}
R10_0 n10 n11 {2551672668419537/25000000000000000000}
C10_1 n10 n11 {75653162673163210000/2551672668419537}
R11_0 n11 n12 {2890449445141633/1250000000000000000}
C11_1 n11 n12 {9598197917016596250/2890449445141633}
R12_0 n12 portn {5344692668821647/1000000000000000000}
C12_1 n12 portn {19483738683015190000/5344692668821647}
.ends NONAGON_POSITIVE_REAL
