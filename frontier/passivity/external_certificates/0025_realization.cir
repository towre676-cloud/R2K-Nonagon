* Exact decimal-rational passive realization; s=+i*2*pi*f_hz
.subckt NONAGON_POSITIVE_REAL portp portn
R0_0 portp n1 {14205696980104609/1000000000000000000}
L1_0 n1 n2 {1894683716608073/20000000000000000000000}
R2_0 n2 n3 {3543071168107953/2000000000000000000}
C2_1 n2 n3 {911674363964239/5905118613513255}
R3_0 n3 n4 {1183535118320389/1000000000000000000}
C3_1 n3 n4 {6939906281779079/11835351183203890}
R4_0 n4 n5 {12845586993366317/10000000000000000000}
C4_1 n4 n5 {17609467116618380/12845586993366317}
R5_0 n5 n6 {4370846063374389/10000000000000000000}
C5_1 n5 n6 {44682639727487750/4370846063374389}
R6_0 n6 n7 {6418676849759741/50000000000000000000}
C6_1 n6 n7 {566893444246332850/6418676849759741}
R7_0 n7 n8 {160847671132323/2000000000000000000}
C7_1 n7 n8 {304433352357512/851045879007}
R8_0 n8 n9 {14368819230500173/100000000000000000000}
C8_1 n8 n9 {7299895561886473000/14368819230500173}
R9_0 n9 n10 {881049977510009/5000000000000000000}
C9_1 n9 n10 {926145582032519150/881049977510009}
R10_0 n10 n11 {2997867299266763/12500000000000000000}
C10_1 n10 n11 {5875054182944291250/2997867299266763}
R11_0 n11 n12 {1432754517040721/2000000000000000000}
C11_1 n11 n12 {2385198168212428400/1432754517040721}
R12_0 n12 n13 {11175975651161073/100000000000000000000}
C12_1 n12 n13 {302612650692652840000/11175975651161073}
R13_0 n13 n14 {22049451583541157/10000000000000000000}
C13_1 n13 n14 {25595194445377590000/7349817194513719}
R14_0 n14 portn {695106790572597/125000000000000000}
C14_1 n14 portn {2435467335376898750/695106790572597}
.ends NONAGON_POSITIVE_REAL
