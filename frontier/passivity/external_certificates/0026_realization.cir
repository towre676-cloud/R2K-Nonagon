* Exact decimal-rational passive realization; s=+i*2*pi*f_hz
.subckt NONAGON_POSITIVE_REAL portp portn
R0_0 portp n1 {3552256310316693/250000000000000000}
L1_0 n1 n2 {1889931258921469/20000000000000000000000}
R2_0 n2 n3 {3564668997111491/2000000000000000000}
C2_1 n2 n3 {2735023091892717/17823344985557455}
R3_0 n3 n4 {10790127233015147/10000000000000000000}
C3_1 n3 n4 {6939906281779079/10790127233015147}
R4_0 n4 n5 {7293147499678709/5000000000000000000}
C4_1 n4 n5 {8804733558309190/7293147499678709}
R5_0 n5 n6 {1338407846769233/2500000000000000000}
C5_1 n5 n6 {22341319863743875/2676815693538466}
R6_0 n6 n7 {854015719219827/4000000000000000000}
C6_1 n6 n7 {291995822475458920/854015719219827}
R7_0 n7 n8 {5386902517054571/50000000000000000000}
C7_1 n7 n8 {9261455820325191500/5386902517054571}
R8_0 n8 n9 {1427479215955991/5000000000000000000}
C8_1 n8 n9 {2350021673177716500/1427479215955991}
R9_0 n9 n10 {3622666266618023/5000000000000000000}
C9_1 n9 n10 {5962995420531071000/3622666266618023}
R10_0 n10 n11 {484376988295059/200000000000000000}
C10_1 n10 n11 {511903888907551800/161458996098353}
R11_0 n11 portn {5407519060121381/1000000000000000000}
C11_1 n11 portn {19483738683015190000/5407519060121381}
.ends NONAGON_POSITIVE_REAL
