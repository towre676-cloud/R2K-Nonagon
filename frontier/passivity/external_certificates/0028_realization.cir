* Exact decimal-rational passive realization; s=+i*2*pi*f_hz
.subckt NONAGON_POSITIVE_REAL portp portn
R0_0 portp n1 {1697851311722951/125000000000000000}
L1_0 n1 n2 {2211211799057607/25000000000000000000000}
R2_0 n2 n3 {18636367794021213/10000000000000000000}
C2_1 n2 n3 {911674363964239/6212122598007071}
R3_0 n3 n4 {5334983753076907/5000000000000000000}
C3_1 n3 n4 {6939906281779079/10669967506153814}
R4_0 n4 n5 {928056826594127/625000000000000000}
C4_1 n4 n5 {4402366779154595/3712227306376508}
R5_0 n5 n6 {30546809404604237/100000000000000000000}
C5_1 n5 n6 {446826397274877500/30546809404604237}
R6_0 n6 n7 {21253907818634483/100000000000000000000}
C6_1 n6 n7 {1133786888492665700/21253907818634483}
R7_0 n7 n8 {3529061528880207/125000000000000000000}
C7_1 n7 n8 {1198706324907703500/1176353842960069}
R8_0 n8 n9 {4330825389754791/25000000000000000000}
C8_1 n8 n9 {1824973890471618250/4330825389754791}
R9_0 n9 n10 {5406619820556911/50000000000000000000}
C9_1 n9 n10 {9261455820325191500/5406619820556911}
R10_0 n10 n11 {3613935969246327/10000000000000000000}
C10_1 n10 n11 {1566681115451811000/1204645323082109}
R11_0 n11 n12 {5799690897645097/10000000000000000000}
C11_1 n11 n12 {11925990841062142000/5799690897645097}
R12_0 n12 n13 {9529111160681171/2500000000000000000}
C12_1 n12 n13 {19196395834033192500/9529111160681171}
R13_0 n13 portn {25791187144845367/10000000000000000000}
C13_1 n13 portn {194837386830151900000/25791187144845367}
.ends NONAGON_POSITIVE_REAL
