* Exact decimal-rational passive realization; s=+i*2*pi*f_hz
.subckt NONAGON_POSITIVE_REAL portp portn
R0_0 portp n1 {13558377365576421/1000000000000000000}
L1_0 n1 n2 {442718623925857/5000000000000000000000}
R2_0 n2 n3 {621314634320407/312500000000000000}
C2_1 n2 n3 {2735023091892717/19882068298253024}
R3_0 n3 n4 {7940385336095583/10000000000000000000}
C3_1 n3 n4 {991415183111297/1134340762299369}
R4_0 n4 n5 {176995033625677/100000000000000000}
C4_1 n4 n5 {880473355830919/884975168128385}
R5_0 n5 n6 {2052243225134019/5000000000000000000}
C5_1 n5 n6 {22341319863743875/2052243225134019}
R6_0 n6 n7 {8142157884632041/10000000000000000000000}
C6_1 n6 n7 {287689517977848840000/8142157884632041}
R7_0 n7 n8 {1420575969096539/6250000000000000000}
C7_1 n7 n8 {912486945235809125/2841151938193078}
R8_0 n8 n9 {4365823769742657/50000000000000000000}
C8_1 n8 n9 {9261455820325191500/4365823769742657}
R9_0 n9 n10 {1280822961807/3906250000000000}
C9_1 n9 n10 {13055675962098425/9108074395072}
R10_0 n10 n11 {6580438935282807/10000000000000000000}
C10_1 n10 n11 {11925990841062142000/6580438935282807}
R11_0 n11 n12 {6682338037200741/2000000000000000000}
C11_1 n11 n12 {5119038889075518000/2227446012400247}
R12_0 n12 portn {1397838548655269/400000000000000000}
C12_1 n12 portn {7793495473206076000/1397838548655269}
.ends NONAGON_POSITIVE_REAL
