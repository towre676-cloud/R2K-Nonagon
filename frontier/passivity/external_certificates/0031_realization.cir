* Exact decimal-rational passive realization; s=+i*2*pi*f_hz
.subckt NONAGON_POSITIVE_REAL portp portn
R0_0 portp n1 {6763033354360277/500000000000000000}
L1_0 n1 n2 {4439619415142409/50000000000000000000000}
R2_0 n2 n3 {3069252396239647/2500000000000000000}
C2_1 n2 n3 {23341470509713713/122770095849585880}
R3_0 n3 n4 {979193856952183/1000000000000000000}
C3_1 n3 n4 {7362960384621947/19583877139043660}
R4_0 n4 n5 {2420630276977777/2000000000000000000}
C4_1 n4 n5 {9158218024914738/12103151384888885}
R5_0 n5 n6 {10037284848613437/10000000000000000000}
C5_1 n5 n6 {22782400830798377/10037284848613437}
R6_0 n6 n7 {1384426329470569/2500000000000000000}
C6_1 n6 n7 {17966511012442207/2768852658941138}
R7_0 n7 n8 {2061270984963353/12500000000000000000}
C7_1 n7 n8 {1382927086045728125/4122541969926706}
R8_0 n8 n9 {1056004112514237/12500000000000000000}
C8_1 n8 n9 {1090595100374874875/1056004112514237}
R9_0 n9 n10 {14846460943390619/500000000000000000000}
C9_1 n9 n10 {108520564386002400000/14846460943390619}
R10_0 n10 n11 {28220331092202323/100000000000000000000}
C10_1 n10 n11 {34232316946716280000/28220331092202323}
R11_0 n11 n12 {2370348556937843/10000000000000000000}
C11_1 n11 n12 {8515787284440447000/2370348556937843}
R12_0 n12 n13 {294771583300259/500000000000000000}
C12_1 n12 n13 {671566562110008200/294771583300259}
R13_0 n13 n14 {1060636821007133/400000000000000000}
C13_1 n13 n14 {3324727621135942800/1060636821007133}
R14_0 n14 portn {35598851152145107/10000000000000000000}
C14_1 n14 portn {131096270015929700000/35598851152145107}
.ends NONAGON_POSITIVE_REAL
