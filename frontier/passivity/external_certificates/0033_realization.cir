* Exact decimal-rational passive realization; s=+i*2*pi*f_hz
.subckt NONAGON_POSITIVE_REAL portp portn
R0_0 portp n1 {6789925634491647/500000000000000000}
L1_0 n1 n2 {1147055541943657/12500000000000000000000}
R2_0 n2 n3 {9799340829511477/5000000000000000000}
C2_1 n2 n3 {2735023091892717/19598681659022954}
R3_0 n3 n4 {4824923812274727/5000000000000000000}
C3_1 n3 n4 {991415183111297/1378549660649922}
R4_0 n4 n5 {15156132997935167/10000000000000000000}
C4_1 n4 n5 {88489784505620/76161472351433}
R5_0 n5 n6 {15255963802325977/50000000000000000000}
C5_1 n5 n6 {223413198637438750/15255963802325977}
R6_0 n6 n7 {9227927058212691/50000000000000000000}
C6_1 n6 n7 {566893444246332850/9227927058212691}
R7_0 n7 n8 {17199727630508867/500000000000000000000}
C7_1 n7 n8 {14384475898892442000/17199727630508867}
R8_0 n8 n9 {901755447623579/6250000000000000000}
C8_1 n8 n9 {912486945235809125/1803510895247158}
R9_0 n9 n10 {7613027133323353/50000000000000000000}
C9_1 n9 n10 {9261455820325191500/7613027133323353}
R10_0 n10 n11 {5594898697908133/20000000000000000000}
C10_1 n10 n11 {9400086692710866000/5594898697908133}
R11_0 n11 n12 {6481493041895337/10000000000000000000}
C11_1 n11 n12 {11925990841062142000/6481493041895337}
R12_0 n12 n13 {1488093801512147/400000000000000000}
C12_1 n12 n13 {3071423333445310800/1488093801512147}
R13_0 n13 portn {532427421113763/200000000000000000}
C13_1 n13 portn {3896747736603038000/532427421113763}
.ends NONAGON_POSITIVE_REAL
