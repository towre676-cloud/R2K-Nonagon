* Exact decimal-rational passive realization; s=+i*2*pi*f_hz
.subckt NONAGON_POSITIVE_REAL portp portn
R0_0 portp n1 {6789701526801907/500000000000000000}
L1_0 n1 n2 {2289056714115967/25000000000000000000000}
R2_0 n2 n3 {20129286406907/10000000000000000}
C2_1 n2 n3 {2735023091892717/20129286406907000}
R3_0 n3 n4 {7432832170430127/10000000000000000000}
C3_1 n3 n4 {6939906281779079/7432832170430127}
R4_0 n4 n5 {2411287307296863/1250000000000000000}
C4_1 n4 n5 {4402366779154595/4822574614593726}
R5_0 n5 n6 {19611424102168677/100000000000000000000}
C5_1 n5 n6 {446826397274877500/19611424102168677}
R6_0 n6 n7 {8868114749371127/100000000000000000000}
C6_1 n6 n7 {2876895179778488400/8868114749371127}
R7_0 n7 n8 {7453240212307309/50000000000000000000}
C7_1 n7 n8 {521421111563319500/1064748601758187}
R8_0 n8 n9 {1421575117532953/10000000000000000000}
C8_1 n8 n9 {1852291164065038300/1421575117532953}
R9_0 n9 n10 {2802654141168429/10000000000000000000}
C9_1 n9 n10 {522227038483937000/311406015685381}
R10_0 n10 n11 {1639446105477531/2500000000000000000}
C10_1 n10 n11 {229345977712733500/126111238882887}
R11_0 n11 n12 {7238615286992353/2000000000000000000}
C11_1 n11 n12 {1396101515202414000/658055935181123}
R12_0 n12 portn {450428302257031/156250000000000000}
C12_1 n12 portn {6088668338442246875/900856604514062}
.ends NONAGON_POSITIVE_REAL
