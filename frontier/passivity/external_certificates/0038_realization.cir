* Exact decimal-rational passive realization; s=+i*2*pi*f_hz
.subckt NONAGON_POSITIVE_REAL portp portn
R0_0 portp n1 {6726511826464971/500000000000000000}
L1_0 n1 n2 {9161461287143541/100000000000000000000000}
R2_0 n2 n3 {10137001142594799/5000000000000000000}
C2_1 n2 n3 {911674363964239/6758000761729866}
R3_0 n3 n4 {7026906067391069/10000000000000000000}
C3_1 n3 n4 {6939906281779079/7026906067391069}
R4_0 n4 n5 {19561298172357817/10000000000000000000}
C4_1 n4 n5 {17609467116618380/19561298172357817}
R5_0 n5 n6 {1576996017776833/10000000000000000000}
C5_1 n5 n6 {44682639727487750/1576996017776833}
R6_0 n6 n7 {11412457439020237/100000000000000000000}
C6_1 n6 n7 {2876895179778488400/11412457439020237}
R7_0 n7 n8 {1364676243048881/10000000000000000000}
C7_1 n7 n8 {104284222312663900/194953749006983}
R8_0 n8 n9 {11068826947939821/100000000000000000000}
C8_1 n8 n9 {18522911640650383000/11068826947939821}
R9_0 n9 n10 {1566128672451019/5000000000000000000}
C9_1 n9 n10 {2350021673177716500/1566128672451019}
R10_0 n10 n11 {617060086072897/1000000000000000000}
C10_1 n10 n11 {1192599084106214200/617060086072897}
R11_0 n11 n12 {37620243370195313/10000000000000000000}
C11_1 n11 n12 {76785583336132770000/37620243370195313}
R12_0 n12 portn {78032669277059/31250000000000000}
C12_1 n12 portn {1217733667688449375/156065338554118}
.ends NONAGON_POSITIVE_REAL
