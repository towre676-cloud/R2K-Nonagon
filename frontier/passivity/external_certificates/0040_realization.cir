* Exact decimal-rational passive realization; s=+i*2*pi*f_hz
.subckt NONAGON_POSITIVE_REAL portp portn
R0_0 portp n1 {3458600843112451/250000000000000000}
L1_0 n1 n2 {9281075592320631/100000000000000000000000}
R2_0 n2 n3 {4105424207005367/2500000000000000000}
C2_1 n2 n3 {2735023091892717/16421696828021468}
R3_0 n3 n4 {14083731641151439/10000000000000000000}
C3_1 n3 n4 {6939906281779079/14083731641151439}
R4_0 n4 n5 {12122047582108233/10000000000000000000}
C4_1 n4 n5 {17609467116618380/12122047582108233}
R5_0 n5 n6 {5515010036539289/10000000000000000000}
C5_1 n5 n6 {44682639727487750/5515010036539289}
R6_0 n6 n7 {114263726619763/2500000000000000000}
C6_1 n6 n7 {56689344424633285/228527453239526}
R7_0 n7 n8 {768945847690819/5000000000000000000}
C7_1 n7 n8 {143844758988924420/768945847690819}
R8_0 n8 n9 {30353050440827127/100000000000000000000}
C8_1 n8 n9 {18522911640650383000/30353050440827127}
R9_0 n9 n10 {18541099827135287/100000000000000000000}
C9_1 n9 n10 {47000433463554330000/18541099827135287}
R10_0 n10 n11 {1637773589711809/2500000000000000000}
C10_1 n10 n11 {2981497710265535500/1637773589711809}
R11_0 n11 n12 {3824187570929783/1000000000000000000}
C11_1 n11 n12 {7678558333613277000/3824187570929783}
R12_0 n12 portn {4814346734660531/2000000000000000000}
C12_1 n12 portn {38967477366030380000/4814346734660531}
.ends NONAGON_POSITIVE_REAL
