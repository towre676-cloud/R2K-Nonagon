* Exact decimal-rational passive realization; s=+i*2*pi*f_hz
.subckt NONAGON_POSITIVE_REAL portp portn
R0_0 portp n1 {2776667163304207/200000000000000000}
L1_0 n1 n2 {9214065847485987/100000000000000000000000}
R2_0 n2 n3 {17711322348951091/10000000000000000000}
C2_1 n2 n3 {2735023091892717/17711322348951091}
R3_0 n3 n4 {11480524864619203/10000000000000000000}
C3_1 n3 n4 {6939906281779079/11480524864619203}
R4_0 n4 n5 {7922616996689153/5000000000000000000}
C4_1 n4 n5 {8804733558309190/7922616996689153}
R5_0 n5 n6 {1043411123307881/2000000000000000000}
C5_1 n5 n6 {8936527945497550/1043411123307881}
R6_0 n6 n7 {226224939700597/1000000000000000000}
C6_1 n6 n7 {72998955618864730/226224939700597}
R7_0 n7 n8 {7104798355356951/100000000000000000000}
C7_1 n7 n8 {18522911640650383000/7104798355356951}
R8_0 n8 n9 {31010591877988667/100000000000000000000}
C8_1 n8 n9 {47000433463554330000/31010591877988667}
R9_0 n9 n10 {3385955496891133/5000000000000000000}
C9_1 n9 n10 {5962995420531071000/3385955496891133}
R10_0 n10 n11 {69851562441163/25000000000000000}
C10_1 n10 n11 {191963958340331925/69851562441163}
R11_0 n11 portn {9205613528601839/2000000000000000000}
C11_1 n11 portn {38967477366030380000/9205613528601839}
.ends NONAGON_POSITIVE_REAL
