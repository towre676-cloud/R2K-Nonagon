* Exact decimal-rational passive realization; s=+i*2*pi*f_hz
.subckt NONAGON_POSITIVE_REAL portp portn
R0_0 portp n1 {13605541097244859/1000000000000000000}
L1_0 n1 n2 {115643981854263/1250000000000000000000}
R2_0 n2 n3 {18627933043982399/10000000000000000000}
C2_1 n2 n3 {2735023091892717/18627933043982399}
R3_0 n3 n4 {5218642128104971/5000000000000000000}
C3_1 n3 n4 {6939906281779079/10437284256209942}
R4_0 n4 n5 {6577079946543697/5000000000000000000}
C4_1 n4 n5 {8804733558309190/6577079946543697}
R5_0 n5 n6 {33611405146027803/100000000000000000000}
C5_1 n5 n6 {446826397274877500/33611405146027803}
R6_0 n6 n7 {1187652690434089/25000000000000000000}
C6_1 n6 n7 {283446722123166425/1187652690434089}
R7_0 n7 n8 {1556807873007579/12500000000000000000}
C7_1 n7 n8 {119870632490770350/518935957669193}
R8_0 n8 n9 {2728030491326217/50000000000000000000}
C8_1 n8 n9 {521421111563319500/389718641618031}
R9_0 n9 n10 {4138982597867173/25000000000000000000}
C9_1 n9 n10 {4630727910162595750/4138982597867173}
R10_0 n10 n11 {3226369104248207/10000000000000000000}
C10_1 n10 n11 {4700043346355433000/3226369104248207}
R11_0 n11 n12 {879195116488923/2000000000000000000}
C11_1 n11 n12 {183476782170186800/67630393576071}
R12_0 n12 n13 {2379768848054451/2500000000000000000}
C12_1 n12 n13 {7565316267316321000/2379768848054451}
R13_0 n13 n14 {8787354001917007/10000000000000000000}
C13_1 n13 n14 {194837386830151900000/8787354001917007}
R14_0 n14 portn {4538050869129509/250000000000000000}
C14_1 n14 portn {12359614154594372500/4538050869129509}
.ends NONAGON_POSITIVE_REAL
