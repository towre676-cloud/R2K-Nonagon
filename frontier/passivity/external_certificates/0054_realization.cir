* Exact decimal-rational passive realization; s=+i*2*pi*f_hz
.subckt NONAGON_POSITIVE_REAL portp portn
R0_0 portp n1 {3402613932996559/250000000000000000}
L1_0 n1 n2 {2307470398888683/25000000000000000000000}
C2_0 n2 n3 {20000000000000000000/6545509653206761}
R3_0 n3 n4 {9440177706491617/5000000000000000000}
C3_1 n3 n4 {2735023091892717/18880355412983234}
R4_0 n4 n5 {85585521421379/100000000000000000}
C4_1 n4 n5 {991415183111297/1222650306019700}
R5_0 n5 n6 {455463589871667/250000000000000000}
C5_1 n5 n6 {880473355830919/910927179743334}
R6_0 n6 n7 {315759807551761/2500000000000000000}
C6_1 n6 n7 {71922379494462210/315759807551761}
R7_0 n7 n8 {6768390507653773/50000000000000000000}
C7_1 n7 n8 {3649947780943236500/6768390507653773}
R8_0 n8 n9 {1002755026707619/12500000000000000000}
C8_1 n8 n9 {2315363955081297875/1002755026707619}
R9_0 n9 n10 {7757880944497499/20000000000000000000}
C9_1 n9 n10 {9400086692710866000/7757880944497499}
R10_0 n10 n11 {1883083209473079/5000000000000000000}
C10_1 n10 n11 {5962995420531071000/1883083209473079}
R11_0 n11 n12 {9890188553706787/10000000000000000000}
C11_1 n11 n12 {30261265069265284000/9890188553706787}
R12_0 n12 portn {7302946568040663/10000000000000000000}
C12_1 n12 portn {25595194445377590000/2434315522680221}
.ends NONAGON_POSITIVE_REAL
