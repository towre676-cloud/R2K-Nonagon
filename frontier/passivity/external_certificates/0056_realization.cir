* Exact decimal-rational passive realization; s=+i*2*pi*f_hz
.subckt NONAGON_POSITIVE_REAL portp portn
R0_0 portp n1 {2742142409051777/200000000000000000}
L1_0 n1 n2 {9269288215476003/100000000000000000000000}
C2_0 n2 n3 {100000000000000000000/32674966531977067}
R3_0 n3 n4 {4298914668986253/2500000000000000000}
C3_1 n3 n4 {911674363964239/5731886225315004}
R4_0 n4 n5 {1314265942188301/1000000000000000000}
C4_1 n4 n5 {6939906281779079/13142659421883010}
R5_0 n5 n6 {301015926421017/250000000000000000}
C5_1 n5 n6 {880473355830919/602031852842034}
R6_0 n6 n7 {2463509346541009/5000000000000000000}
C6_1 n6 n7 {22341319863743875/2463509346541009}
R7_0 n7 n8 {11012156652476107/500000000000000000000}
C7_1 n7 n8 {5668934442463328500/11012156652476107}
R8_0 n8 n9 {1320288131223059/10000000000000000000}
C8_1 n8 n9 {287689517977848840/1320288131223059}
R9_0 n9 n10 {1864793622105703/50000000000000000000}
C9_1 n9 n10 {3649947780943236500/1864793622105703}
R10_0 n10 n11 {10367171975911531/50000000000000000000}
C10_1 n10 n11 {9261455820325191500/10367171975911531}
R11_0 n11 n12 {25637683987514713/100000000000000000000}
C11_1 n11 n12 {47000433463554330000/25637683987514713}
R12_0 n12 n13 {1017703546415827/2000000000000000000}
C12_1 n12 n13 {2385198168212428400/1017703546415827}
R13_0 n13 n14 {7965247793938339/10000000000000000000}
C13_1 n13 n14 {30261265069265284000/7965247793938339}
R14_0 n14 portn {9538946255550473/10000000000000000000}
C14_1 n14 portn {76785583336132770000/9538946255550473}
.ends NONAGON_POSITIVE_REAL
