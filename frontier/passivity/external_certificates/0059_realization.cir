* Exact decimal-rational passive realization; s=+i*2*pi*f_hz
.subckt NONAGON_POSITIVE_REAL portp portn
R0_0 portp n1 {54582553620851/4000000000000000}
L1_0 n1 n2 {466546584165523/5000000000000000000000}
C2_0 n2 n3 {10000000000000000000/2963935832182479}
R3_0 n3 n4 {9866131342661643/5000000000000000000}
C3_1 n3 n4 {911674363964239/6577420895107762}
R4_0 n4 n5 {4255000039331081/5000000000000000000}
C4_1 n4 n5 {6939906281779079/8510000078662162}
R5_0 n5 n6 {18125870628926287/10000000000000000000}
C5_1 n5 n6 {17609467116618380/18125870628926287}
R6_0 n6 n7 {6343270431843197/50000000000000000000}
C6_1 n6 n7 {223413198637438750/6343270431843197}
R7_0 n7 n8 {9521830506809219/50000000000000000000}
C7_1 n7 n8 {1438447589889244200/9521830506809219}
R8_0 n8 n9 {1638338745813749/50000000000000000000}
C8_1 n8 n9 {521421111563319500/234048392259107}
R9_0 n9 n10 {2581991805571063/12500000000000000000}
C9_1 n9 n10 {2315363955081297875/2581991805571063}
R10_0 n10 n11 {25018852166878443/100000000000000000000}
C10_1 n10 n11 {15666811154518110000/8339617388959481}
R11_0 n11 n12 {1412103444649087/2500000000000000000}
C11_1 n11 n12 {2981497710265535500/1412103444649087}
R12_0 n12 n13 {2806325955533277/5000000000000000000}
C12_1 n12 n13 {15130632534632642000/2806325955533277}
R13_0 n13 portn {15092260126857917/10000000000000000000}
C13_1 n13 portn {76785583336132770000/15092260126857917}
.ends NONAGON_POSITIVE_REAL
