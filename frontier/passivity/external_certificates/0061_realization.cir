* Exact decimal-rational passive realization; s=+i*2*pi*f_hz
.subckt NONAGON_POSITIVE_REAL portp portn
R0_0 portp n1 {2729404901365477/200000000000000000}
L1_0 n1 n2 {4702719403330871/50000000000000000000000}
C2_0 n2 n3 {10000000000000000000/2934675379634279}
R3_0 n3 n4 {1966427284665007/1000000000000000000}
C3_1 n3 n4 {2735023091892717/19664272846650070}
R4_0 n4 n5 {8450162906136223/10000000000000000000}
C4_1 n4 n5 {6939906281779079/8450162906136223}
R5_0 n5 n6 {13624759126341643/10000000000000000000}
C5_1 n5 n6 {17609467116618380/13624759126341643}
R6_0 n6 n7 {9255088115335659/50000000000000000000}
C6_1 n6 n7 {223413198637438750/9255088115335659}
R7_0 n7 n8 {7710070993086563/50000000000000000000}
C7_1 n7 n8 {566893444246332850/7710070993086563}
R8_0 n8 n9 {29579630030337/2000000000000000000}
C8_1 n8 n9 {19179301198523256/9859876676779}
R9_0 n9 n10 {6357416307330113/50000000000000000000}
C9_1 n9 n10 {3649947780943236500/6357416307330113}
R10_0 n10 n11 {11869201616258609/100000000000000000000}
C10_1 n10 n11 {18522911640650383000/11869201616258609}
R11_0 n11 n12 {6619361292384547/20000000000000000000}
C11_1 n11 n12 {9400086692710866000/6619361292384547}
R12_0 n12 n13 {4578744461797341/10000000000000000000}
C12_1 n12 n13 {11925990841062142000/4578744461797341}
R13_0 n13 n14 {6827940113958001/10000000000000000000}
C13_1 n13 n14 {30261265069265284000/6827940113958001}
R14_0 n14 portn {1685940900324253/1250000000000000000}
C14_1 n14 portn {9598197917016596250/1685940900324253}
.ends NONAGON_POSITIVE_REAL
