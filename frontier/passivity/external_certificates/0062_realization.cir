* Exact decimal-rational passive realization; s=+i*2*pi*f_hz
.subckt NONAGON_POSITIVE_REAL portp portn
R0_0 portp n1 {13655409098144177/1000000000000000000}
L1_0 n1 n2 {938168129930137/10000000000000000000000}
C2_0 n2 n3 {12500000000000000/3901917975853}
R3_0 n3 n4 {9886496538208287/5000000000000000000}
C3_1 n3 n4 {911674363964239/6590997692138858}
R4_0 n4 n5 {867366226531657/1250000000000000000}
C4_1 n4 n5 {6939906281779079/6938929812253256}
R5_0 n5 n6 {8913047733621139/5000000000000000000}
C5_1 n5 n6 {44244892252810/44789184591061}
R6_0 n6 n7 {1764024131444533/50000000000000000000}
C6_1 n6 n7 {205492512841320600/252003447349219}
R7_0 n7 n8 {22711278301769587/100000000000000000000}
C7_1 n7 n8 {7299895561886473000/22711278301769587}
R8_0 n8 n9 {20981547281822833/50000000000000000000}
C8_1 n8 n9 {23500216731777165000/20981547281822833}
R9_0 n9 n10 {38448764965436457/100000000000000000000}
C9_1 n9 n10 {119259908410621420000/38448764965436457}
R10_0 n10 n11 {8261579221791323/10000000000000000000}
C10_1 n10 n11 {30261265069265284000/8261579221791323}
R11_0 n11 portn {10236096357122129/10000000000000000000}
C11_1 n11 portn {76785583336132770000/10236096357122129}
.ends NONAGON_POSITIVE_REAL
