* Exact decimal-rational passive realization; s=+i*2*pi*f_hz
.subckt NONAGON_POSITIVE_REAL portp portn
R0_0 portp n1 {6816323969406587/500000000000000000}
L1_0 n1 n2 {4641964556339917/50000000000000000000000}
C2_0 n2 n3 {2500000000000000000/905546361553499}
R3_0 n3 n4 {4195139052091237/2500000000000000000}
C3_1 n3 n4 {2735023091892717/16780556208364948}
R4_0 n4 n5 {1540972999153677/1250000000000000000}
C4_1 n4 n5 {6939906281779079/12327783993229416}
R5_0 n5 n6 {5183436801198347/5000000000000000000}
C5_1 n5 n6 {8804733558309190/5183436801198347}
R6_0 n6 n7 {275621585386713/800000000000000000}
C6_1 n6 n7 {3574611178199020/275621585386713}
R7_0 n7 n8 {7134182243393647/125000000000000000000}
C7_1 n7 n8 {1417233610615832125/7134182243393647}
R8_0 n8 n9 {651526237030473/6250000000000000000}
C8_1 n8 n9 {951354226117225/3447228767357}
R9_0 n9 n10 {2512217409953391/50000000000000000000}
C9_1 n9 n10 {521421111563319500/358888201421913}
R10_0 n10 n11 {574302231899453/3125000000000000000}
C10_1 n10 n11 {2315363955081297875/2297208927597812}
R11_0 n11 n12 {6746402750212433/20000000000000000000}
C11_1 n11 n12 {9400086692710866000/6746402750212433}
R12_0 n12 n13 {1360389902920223/4000000000000000000}
C12_1 n12 n13 {4770396336424856800/1360389902920223}
R13_0 n13 n14 {12059524255848837/10000000000000000000}
C13_1 n13 n14 {30261265069265284000/12059524255848837}
R14_0 n14 portn {12034107903468321/100000000000000000000}
C14_1 n14 portn {7756119528902300000/121556645489579}
.ends NONAGON_POSITIVE_REAL
