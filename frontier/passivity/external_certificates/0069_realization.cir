* Exact decimal-rational passive realization; s=+i*2*pi*f_hz
.subckt NONAGON_POSITIVE_REAL portp portn
R0_0 portp n1 {271563058656253/20000000000000000}
L1_0 n1 n2 {9169393560954637/100000000000000000000000}
C2_0 n2 n3 {100000000000000000000/25029500756961707}
R3_0 n3 n4 {978226146870381/500000000000000000}
C3_1 n3 n4 {911674363964239/6521507645802540}
R4_0 n4 n5 {457966154532151/625000000000000000}
C4_1 n4 n5 {6939906281779079/7327458472514416}
R5_0 n5 n6 {86426262057767/62500000000000000}
C5_1 n5 n6 {880473355830919/691410096462136}
R6_0 n6 n7 {4759600678837031/100000000000000000000}
C6_1 n6 n7 {446826397274877500/4759600678837031}
R7_0 n7 n8 {238417105402649/1250000000000000000}
C7_1 n7 n8 {56689344424633285/953668421610596}
R8_0 n8 n9 {17792510575545647/500000000000000000000}
C8_1 n8 n9 {14384475898892442000/17792510575545647}
R9_0 n9 n10 {1044929762101431/10000000000000000000}
C9_1 n9 n10 {729989556188647300/1044929762101431}
R10_0 n10 n11 {1438268398536603/10000000000000000000}
C10_1 n10 n11 {1852291164065038300/1438268398536603}
R11_0 n11 n12 {1661489406774683/5000000000000000000}
C11_1 n11 n12 {2350021673177716500/1661489406774683}
R12_0 n12 n13 {127295700800603/250000000000000000}
C12_1 n12 n13 {298149771026553550/127295700800603}
R13_0 n13 n14 {3114831479879001/5000000000000000000}
C13_1 n13 n14 {15130632534632642000/3114831479879001}
R14_0 n14 n15 {12861877270468657/10000000000000000000}
C14_1 n14 n15 {76785583336132770000/12861877270468657}
R15_0 n15 portn {5389858209073749/5000000000000000000}
C15_1 n15 portn {97418693415075950000/5389858209073749}
.ends NONAGON_POSITIVE_REAL
