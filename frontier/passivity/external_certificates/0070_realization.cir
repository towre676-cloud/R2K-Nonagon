* Exact decimal-rational passive realization; s=+i*2*pi*f_hz
.subckt NONAGON_POSITIVE_REAL portp portn
R0_0 portp n1 {13580864018864687/1000000000000000000}
L1_0 n1 n2 {4573279345281771/50000000000000000000000}
C2_0 n2 n3 {25000000000000000000/7036197470445861}
R3_0 n3 n4 {19372509398477343/10000000000000000000}
C3_1 n3 n4 {911674363964239/6457503132825781}
R4_0 n4 n5 {3502910116177567/5000000000000000000}
C4_1 n4 n5 {6939906281779079/7005820232355134}
R5_0 n5 n6 {16213688884342493/10000000000000000000}
C5_1 n5 n6 {17609467116618380/16213688884342493}
R6_0 n6 n7 {1581435657924697/40000000000000000000}
C6_1 n6 n7 {1150758071911395360/1581435657924697}
R7_0 n7 n8 {2050958937147243/10000000000000000000}
C7_1 n7 n8 {729989556188647300/2050958937147243}
R8_0 n8 n9 {6790023492047269/100000000000000000000}
C8_1 n8 n9 {18522911640650383000/6790023492047269}
R9_0 n9 n10 {3477688282163013/10000000000000000000}
C9_1 n9 n10 {1566681115451811000/1159229427387671}
R10_0 n10 n11 {1315328430642473/2500000000000000000}
C10_1 n10 n11 {229345977712733500/101179110049421}
R11_0 n11 n12 {1477021666077623/2500000000000000000}
C11_1 n11 n12 {7565316267316321000/1477021666077623}
R12_0 n12 portn {1902425248008423/1250000000000000000}
C12_1 n12 portn {1066466435224066250/211380583112047}
.ends NONAGON_POSITIVE_REAL
