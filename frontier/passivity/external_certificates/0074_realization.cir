* Exact decimal-rational passive realization; s=+i*2*pi*f_hz
.subckt NONAGON_POSITIVE_REAL portp portn
R0_0 portp n1 {6846351920009543/500000000000000000}
L1_0 n1 n2 {4654056545948669/50000000000000000000000}
C2_0 n2 n3 {10000000000000000000/3133480625881563}
R3_0 n3 n4 {601414489830193/312500000000000000}
C3_1 n3 n4 {2735023091892717/19245263674566176}
R4_0 n4 n5 {1320938310889333/2000000000000000000}
C4_1 n4 n5 {6939906281779079/6604691554446665}
R5_0 n5 n6 {8049040174022689/5000000000000000000}
C5_1 n5 n6 {8804733558309190/8049040174022689}
R6_0 n6 n7 {8912664866203273/500000000000000000000}
C6_1 n6 n7 {2054925128413206000/1273237838029039}
R7_0 n7 n8 {2287856257742413/10000000000000000000}
C7_1 n7 n8 {729989556188647300/2287856257742413}
R8_0 n8 n9 {2976972881060141/100000000000000000000}
C8_1 n8 n9 {18522911640650383000/2976972881060141}
R9_0 n9 n10 {44487962723129237/100000000000000000000}
C9_1 n9 n10 {47000433463554330000/44487962723129237}
R10_0 n10 n11 {31841189484412057/100000000000000000000}
C10_1 n10 n11 {119259908410621420000/31841189484412057}
R11_0 n11 n12 {5261023813432353/5000000000000000000}
C11_1 n11 n12 {15130632534632642000/5261023813432353}
R12_0 n12 portn {7504912179247329/10000000000000000000}
C12_1 n12 portn {775611952890230000/75807193729771}
.ends NONAGON_POSITIVE_REAL
