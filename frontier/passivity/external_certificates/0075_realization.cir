* Exact decimal-rational passive realization; s=+i*2*pi*f_hz
.subckt NONAGON_POSITIVE_REAL portp portn
R0_0 portp n1 {3415622525160071/250000000000000000}
L1_0 n1 n2 {1866715813150907/20000000000000000000000}
C2_0 n2 n3 {5000000000000000000/1410542336905817}
R3_0 n3 n4 {9989024066618603/5000000000000000000}
C3_1 n3 n4 {2735023091892717/19978048133237206}
R4_0 n4 n5 {6011232408082947/10000000000000000000}
C4_1 n4 n5 {6939906281779079/6011232408082947}
R5_0 n5 n6 {396358686931757/250000000000000000}
C5_1 n5 n6 {880473355830919/792717373863514}
R6_0 n6 n7 {1526974312532827/12500000000000000000}
C6_1 n6 n7 {359611897472311050/1526974312532827}
R7_0 n7 n8 {10132766465284711/100000000000000000000}
C7_1 n7 n8 {7299895561886473000/10132766465284711}
R8_0 n8 n9 {2748126482285967/20000000000000000000}
C8_1 n8 n9 {3704582328130076600/2748126482285967}
R9_0 n9 n10 {34867103953795277/100000000000000000000}
C9_1 n9 n10 {47000433463554330000/34867103953795277}
R10_0 n10 n11 {46518904135764953/100000000000000000000}
C10_1 n10 n11 {119259908410621420000/46518904135764953}
R11_0 n11 n12 {1814242145646327/2500000000000000000}
C11_1 n11 n12 {7565316267316321000/1814242145646327}
R12_0 n12 portn {1729141322347621/1250000000000000000}
C12_1 n12 portn {9598197917016596250/1729141322347621}
.ends NONAGON_POSITIVE_REAL
