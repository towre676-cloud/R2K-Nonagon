* Exact decimal-rational passive realization; s=+i*2*pi*f_hz
.subckt NONAGON_POSITIVE_REAL portp portn
R0_0 portp n1 {6748871258700907/500000000000000000}
L1_0 n1 n2 {118761182500773/1250000000000000000000}
C2_0 n2 n3 {250000000000000000/73174685305247}
R3_0 n3 n4 {18932916315135917/10000000000000000000}
C3_1 n3 n4 {2735023091892717/18932916315135917}
R4_0 n4 n5 {1024495151496949/1250000000000000000}
C4_1 n4 n5 {6939906281779079/8195961211975592}
R5_0 n5 n6 {12430100826393699/10000000000000000000}
C5_1 n5 n6 {17609467116618380/12430100826393699}
R6_0 n6 n7 {386158455153511/2500000000000000000}
C6_1 n6 n7 {22341319863743875/772316910307022}
R7_0 n7 n8 {146393983370661/1562500000000000000}
C7_1 n7 n8 {283446722123166425/2342303733930576}
R8_0 n8 n9 {1908609574255857/20000000000000000000}
C8_1 n8 n9 {63931003995077520/212067730472873}
R9_0 n9 n10 {6462173535735443/100000000000000000000}
C9_1 n9 n10 {7299895561886473000/6462173535735443}
R10_0 n10 n11 {13726912564405343/100000000000000000000}
C10_1 n10 n11 {18522911640650383000/13726912564405343}
R11_0 n11 n12 {6926889993419061/20000000000000000000}
C11_1 n11 n12 {1044454076967874000/769654443713229}
R12_0 n12 n13 {11146921516762459/25000000000000000000}
C12_1 n12 n13 {29814977102655355000/11146921516762459}
R13_0 n13 n14 {6960897143086871/10000000000000000000}
C13_1 n13 n14 {30261265069265284000/6960897143086871}
R14_0 n14 portn {13045517721661031/10000000000000000000}
C14_1 n14 portn {76785583336132770000/13045517721661031}
.ends NONAGON_POSITIVE_REAL
