* Exact decimal-rational passive realization; s=+i*2*pi*f_hz
.subckt NONAGON_POSITIVE_REAL portp portn
R0_0 portp n1 {13502118273045781/1000000000000000000}
L1_0 n1 n2 {189661768123161/2000000000000000000000}
C2_0 n2 n3 {20000000000000000000/6540788700731239}
R3_0 n3 n4 {239371119998731/125000000000000000}
C3_1 n3 n4 {2735023091892717/19149689599898480}
R4_0 n4 n5 {6715589660134787/10000000000000000000}
C4_1 n4 n5 {6939906281779079/6715589660134787}
R5_0 n5 n6 {16074699033326687/10000000000000000000}
C5_1 n5 n6 {17609467116618380/16074699033326687}
R6_0 n6 n7 {54059678649049/2500000000000000000}
C6_1 n6 n7 {71922379494462210/54059678649049}
R7_0 n7 n8 {2256946498403757/10000000000000000000}
C7_1 n7 n8 {729989556188647300/2256946498403757}
R8_0 n8 n9 {2304738698538287/5000000000000000000}
C8_1 n8 n9 {2350021673177716500/2304738698538287}
R9_0 n9 n10 {2917093948409269/10000000000000000000}
C9_1 n9 n10 {11925990841062142000/2917093948409269}
R10_0 n10 n11 {10365094255914149/10000000000000000000}
C10_1 n10 n11 {30261265069265284000/10365094255914149}
R11_0 n11 portn {3126779572436091/5000000000000000000}
C11_1 n11 portn {387805976445115000/31583632044809}
.ends NONAGON_POSITIVE_REAL
