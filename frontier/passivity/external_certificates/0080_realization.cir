* Exact decimal-rational passive realization; s=+i*2*pi*f_hz
.subckt NONAGON_POSITIVE_REAL portp portn
R0_0 portp n1 {6772238116402581/500000000000000000}
L1_0 n1 n2 {1854823953632497/20000000000000000000000}
C2_0 n2 n3 {10000000000000000000/3773432123749933}
R3_0 n3 n4 {4148440748084571/2500000000000000000}
C3_1 n3 n4 {911674363964239/5531254330779428}
R4_0 n4 n5 {6011529323125339/5000000000000000000}
C4_1 n4 n5 {6939906281779079/12023058646250678}
R5_0 n5 n6 {1949769004687477/2000000000000000000}
C5_1 n5 n6 {3521893423323676/1949769004687477}
R6_0 n6 n7 {1397373992410651/5000000000000000000}
C6_1 n6 n7 {22341319863743875/1397373992410651}
R7_0 n7 n8 {4423373980098199/50000000000000000000}
C7_1 n7 n8 {566893444246332850/4423373980098199}
R8_0 n8 n9 {24345234590247427/1000000000000000000000}
C8_1 n8 n9 {28768951797784884000/24345234590247427}
R9_0 n9 n10 {289195610769097/2000000000000000000}
C9_1 n9 n10 {145997911237729460/289195610769097}
R10_0 n10 n11 {860914419838077/12500000000000000000}
C10_1 n10 n11 {2315363955081297875/860914419838077}
R11_0 n11 n12 {1960062973371683/5000000000000000000}
C11_1 n11 n12 {2350021673177716500/1960062973371683}
R12_0 n12 n13 {646237514751171/2000000000000000000}
C12_1 n12 n13 {2385198168212428400/646237514751171}
R13_0 n13 portn {456051681453827/400000000000000000}
C13_1 n13 portn {1210450602770611360/456051681453827}
.ends NONAGON_POSITIVE_REAL
