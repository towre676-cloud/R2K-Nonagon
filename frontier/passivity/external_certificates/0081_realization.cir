* Exact decimal-rational passive realization; s=+i*2*pi*f_hz
.subckt NONAGON_POSITIVE_REAL portp portn
R0_0 portp n1 {210924881854739/15625000000000000}
L1_0 n1 n2 {2333577472516811/25000000000000000000000}
C2_0 n2 n3 {10000000000000000000/3604545186612591}
R3_0 n3 n4 {9183815549991401/5000000000000000000}
C3_1 n3 n4 {2735023091892717/18367631099982802}
R4_0 n4 n5 {9157452719821531/10000000000000000000}
C4_1 n4 n5 {6939906281779079/9157452719821531}
R5_0 n5 n6 {12437242166415867/10000000000000000000}
C5_1 n5 n6 {17609467116618380/12437242166415867}
R6_0 n6 n7 {5472122991340951/50000000000000000000}
C6_1 n6 n7 {223413198637438750/5472122991340951}
R7_0 n7 n8 {76611103151111/500000000000000000}
C7_1 n7 n8 {11337868884926657/153222206302222}
R8_0 n8 n9 {231669114099611/12500000000000000000}
C8_1 n8 n9 {359611897472311050/231669114099611}
R9_0 n9 n10 {6710741084533691/50000000000000000000}
C9_1 n9 n10 {3649947780943236500/6710741084533691}
R10_0 n10 n11 {8122013518570181/100000000000000000000}
C10_1 n10 n11 {18522911640650383000/8122013518570181}
R11_0 n11 n12 {484309427718411/1250000000000000000}
C11_1 n11 n12 {65278379810492125/53812158635379}
R12_0 n12 n13 {1689449408519323/5000000000000000000}
C12_1 n12 n13 {5962995420531071000/1689449408519323}
R13_0 n13 n14 {5121217330810587/5000000000000000000}
C13_1 n13 n14 {15130632534632642000/5121217330810587}
R14_0 n14 portn {3017167872235131/10000000000000000000}
C14_1 n14 portn {25595194445377590000/1005722624078377}
.ends NONAGON_POSITIVE_REAL
