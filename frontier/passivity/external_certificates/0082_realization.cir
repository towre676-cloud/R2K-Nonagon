* Exact decimal-rational passive realization; s=+i*2*pi*f_hz
.subckt NONAGON_POSITIVE_REAL portp portn
R0_0 portp n1 {337655425226213/25000000000000000}
L1_0 n1 n2 {9284958484881979/100000000000000000000000}
C2_0 n2 n3 {20000000000000000000/7471094967189903}
R3_0 n3 n4 {18511818726570889/10000000000000000000}
C3_1 n3 n4 {2735023091892717/18511818726570889}
R4_0 n4 n5 {317268587848997/400000000000000000}
C4_1 n4 n5 {6939906281779079/7931714696224925}
R5_0 n5 n6 {7739223372165843/5000000000000000000}
C5_1 n5 n6 {8804733558309190/7739223372165843}
R6_0 n6 n7 {18195309551293677/500000000000000000000}
C6_1 n6 n7 {1598275099876938000/2021701061254853}
R7_0 n7 n8 {2244389037694089/10000000000000000000}
C7_1 n7 n8 {56153042783742100/172645310591853}
R8_0 n8 n9 {22514868478794883/50000000000000000000}
C8_1 n8 n9 {23500216731777165000/22514868478794883}
R9_0 n9 n10 {2555791662479567/10000000000000000000}
C9_1 n9 n10 {11925990841062142000/2555791662479567}
R10_0 n10 portn {2390122677666149/2000000000000000000}
C10_1 n10 portn {6052253013853056800/2390122677666149}
.ends NONAGON_POSITIVE_REAL
