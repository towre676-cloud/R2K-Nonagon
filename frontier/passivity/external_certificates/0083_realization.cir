* Exact decimal-rational passive realization; s=+i*2*pi*f_hz
.subckt NONAGON_POSITIVE_REAL portp portn
R0_0 portp n1 {269439708002103/20000000000000000}
L1_0 n1 n2 {1866898829098001/20000000000000000000000}
C2_0 n2 n3 {625000000000000000/226418352244997}
R3_0 n3 n4 {3860464392664581/2000000000000000000}
C3_1 n3 n4 {911674363964239/6434107321107635}
R4_0 n4 n5 {143896973495567/200000000000000000}
C4_1 n4 n5 {6939906281779079/7194848674778350}
R5_0 n5 n6 {15456996187204921/10000000000000000000}
C5_1 n5 n6 {17609467116618380/15456996187204921}
R6_0 n6 n7 {13427454241231673/100000000000000000000}
C6_1 n6 n7 {2876895179778488400/13427454241231673}
R7_0 n7 n8 {9759214520661593/100000000000000000000}
C7_1 n7 n8 {561530427837421000/750708809281661}
R8_0 n8 n9 {2401197730344029/25000000000000000000}
C8_1 n8 n9 {4630727910162595750/2401197730344029}
R9_0 n9 n10 {3891308691876013/10000000000000000000}
C9_1 n9 n10 {4700043346355433000/3891308691876013}
R10_0 n10 n11 {3158275596893279/10000000000000000000}
C10_1 n10 n11 {11925990841062142000/3158275596893279}
R11_0 n11 n12 {534763750691/500000000000000}
C11_1 n11 n12 {7565316267316321/2673818753455}
R12_0 n12 portn {5981363407577573/25000000000000000000}
C12_1 n12 portn {191963958340331925000/5981363407577573}
.ends NONAGON_POSITIVE_REAL
