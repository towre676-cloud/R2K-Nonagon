* Exact decimal-rational passive realization; s=+i*2*pi*f_hz
.subckt NONAGON_POSITIVE_REAL portp portn
R0_0 portp n1 {13389303756713647/1000000000000000000}
L1_0 n1 n2 {4653346097986917/50000000000000000000000}
R2_0 n2 n3 {521752201601629/312500000000000000}
C2_1 n2 n3 {2735023091892717/16696070451252128}
R3_0 n3 n4 {4427465081361767/5000000000000000000}
C3_1 n3 n4 {6939906281779079/8854930162723534}
R4_0 n4 n5 {2297807863569587/2500000000000000000}
C4_1 n4 n5 {4402366779154595/2297807863569587}
R5_0 n5 n6 {2513162895543129/25000000000000000000}
C5_1 n5 n6 {111706599318719375/2513162895543129}
R6_0 n6 n7 {831722553933623/5000000000000000000}
C6_1 n6 n7 {56689344424633285/831722553933623}
R7_0 n7 n8 {22520715880991297/100000000000000000000}
C7_1 n7 n8 {7299895561886473000/22520715880991297}
R8_0 n8 n9 {2653978983389179/50000000000000000000}
C8_1 n8 n9 {9261455820325191500/2653978983389179}
R9_0 n9 n10 {4019188104769403/10000000000000000000}
C9_1 n9 n10 {4700043346355433000/4019188104769403}
R10_0 n10 n11 {581307137768941/1000000000000000000}
C10_1 n10 n11 {1192599084106214200/581307137768941}
R11_0 n11 n12 {1915685950702127/500000000000000000}
C11_1 n11 n12 {3839279166806638500/1915685950702127}
R12_0 n12 portn {4282255613400291/2000000000000000000}
C12_1 n12 portn {2050919861370020000/225381874389489}
.ends NONAGON_POSITIVE_REAL
