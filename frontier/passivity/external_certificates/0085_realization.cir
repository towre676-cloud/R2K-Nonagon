* Exact decimal-rational passive realization; s=+i*2*pi*f_hz
.subckt NONAGON_POSITIVE_REAL portp portn
R0_0 portp n1 {13356227894107873/1000000000000000000}
L1_0 n1 n2 {4679079263513239/50000000000000000000000}
R2_0 n2 n3 {17829357890240597/10000000000000000000}
C2_1 n2 n3 {2735023091892717/17829357890240597}
R3_0 n3 n4 {3782831909124287/5000000000000000000}
C3_1 n3 n4 {6939906281779079/7565663818248574}
R4_0 n4 n5 {978803985076311/1000000000000000000}
C4_1 n4 n5 {1760946711661838/978803985076311}
R5_0 n5 n6 {5127974449117187/50000000000000000000}
C5_1 n5 n6 {223413198637438750/5127974449117187}
R6_0 n6 n7 {7440020958962657/50000000000000000000}
C6_1 n6 n7 {566893444246332850/7440020958962657}
R7_0 n7 n8 {5060934386167711/500000000000000000000}
C7_1 n7 n8 {14384475898892442000/5060934386167711}
R8_0 n8 n9 {9851066715317219/50000000000000000000}
C8_1 n8 n9 {521421111563319500/1407295245045317}
R9_0 n9 n10 {6267487341319751/50000000000000000000}
C9_1 n9 n10 {9261455820325191500/6267487341319751}
R10_0 n10 n11 {613046059861137/2000000000000000000}
C10_1 n10 n11 {313336223090362200/204348686620379}
R11_0 n11 n12 {1348009518913459/2000000000000000000}
C11_1 n11 n12 {2385198168212428400/1348009518913459}
R12_0 n12 n13 {7001327041720861/2000000000000000000}
C12_1 n12 n13 {15357116667226554000/7001327041720861}
R13_0 n13 portn {27302685108889367/10000000000000000000}
C13_1 n13 portn {194837386830151900000/27302685108889367}
.ends NONAGON_POSITIVE_REAL
