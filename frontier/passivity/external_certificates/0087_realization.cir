* Exact decimal-rational passive realization; s=+i*2*pi*f_hz
.subckt NONAGON_POSITIVE_REAL portp portn
R0_0 portp n1 {13331066574502507/1000000000000000000}
L1_0 n1 n2 {293085980490537/3125000000000000000000}
R2_0 n2 n3 {751608433388057/400000000000000000}
C2_1 n2 n3 {2735023091892717/18790210834701425}
R3_0 n3 n4 {5454599032335781/10000000000000000000}
C3_1 n3 n4 {6939906281779079/5454599032335781}
R4_0 n4 n5 {6319439201317693/5000000000000000000}
C4_1 n4 n5 {8804733558309190/6319439201317693}
R5_0 n5 n6 {236101731027529/2500000000000000000}
C5_1 n5 n6 {22341319863743875/472203462055058}
R6_0 n6 n7 {1134080574785693/100000000000000000000}
C6_1 n6 n7 {2876895179778488400/1134080574785693}
R7_0 n7 n8 {1511458987184357/6250000000000000000}
C7_1 n7 n8 {912486945235809125/3022917974368714}
R8_0 n8 n9 {6381047623568559/100000000000000000000}
C8_1 n8 n9 {18522911640650383000/6381047623568559}
R9_0 n9 n10 {1786715746645917/5000000000000000000}
C9_1 n9 n10 {783340557725905500/595571915548639}
R10_0 n10 n11 {3266118310461737/5000000000000000000}
C10_1 n10 n11 {5962995420531071000/3266118310461737}
R11_0 n11 n12 {34436780810636553/10000000000000000000}
C11_1 n11 n12 {8531731481792530000/3826308978959617}
R12_0 n12 portn {2874303799156717/1000000000000000000}
C12_1 n12 portn {19483738683015190000/2874303799156717}
.ends NONAGON_POSITIVE_REAL
