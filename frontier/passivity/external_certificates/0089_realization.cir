* Exact decimal-rational passive realization; s=+i*2*pi*f_hz
.subckt NONAGON_POSITIVE_REAL portp portn
R0_0 portp n1 {2786077412442571/200000000000000000}
L1_0 n1 n2 {9570419257734573/100000000000000000000000}
C2_0 n2 n3 {50000000000000000000/10335591125407853}
R3_0 n3 n4 {15737246248840237/10000000000000000000}
C3_1 n3 n4 {2735023091892717/15737246248840237}
R4_0 n4 n5 {217477261134999/200000000000000000}
C4_1 n4 n5 {6939906281779079/10873863056749950}
R5_0 n5 n6 {21750133107013/25000000000000000}
C5_1 n5 n6 {880473355830919/435002662140260}
R6_0 n6 n7 {3004581995470297/10000000000000000000}
C6_1 n6 n7 {44682639727487750/3004581995470297}
R7_0 n7 n8 {29853276722226043/500000000000000000000}
C7_1 n7 n8 {36499477809432365000/29853276722226043}
R8_0 n8 n9 {2105470471055753/10000000000000000000}
C8_1 n8 n9 {1852291164065038300/2105470471055753}
R9_0 n9 n10 {28488606849178823/100000000000000000000}
C9_1 n9 n10 {47000433463554330000/28488606849178823}
R10_0 n10 n11 {2837197282309819/5000000000000000000}
C10_1 n10 n11 {458691955425467000/218245944793063}
R11_0 n11 n12 {2014458348250663/5000000000000000000}
C11_1 n11 n12 {15130632534632642000/2014458348250663}
R12_0 n12 portn {24029440344401757/10000000000000000000}
C12_1 n12 portn {25595194445377590000/8009813448133919}
.ends NONAGON_POSITIVE_REAL
