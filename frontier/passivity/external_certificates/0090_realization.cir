* Exact decimal-rational passive realization; s=+i*2*pi*f_hz
.subckt NONAGON_POSITIVE_REAL portp portn
R0_0 portp n1 {3483860827793099/250000000000000000}
L1_0 n1 n2 {2385393873368091/25000000000000000000000}
R2_0 n2 n3 {15489442002078909/10000000000000000000}
C2_1 n2 n3 {911674363964239/5163147334026303}
R3_0 n3 n4 {10828704593891453/10000000000000000000}
C3_1 n3 n4 {6939906281779079/10828704593891453}
R4_0 n4 n5 {10917499149077571/10000000000000000000}
C4_1 n4 n5 {17609467116618380/10917499149077571}
R5_0 n5 n6 {2548801165895157/10000000000000000000}
C5_1 n5 n6 {729989556188647300/2548801165895157}
R6_0 n6 n7 {3140955158567581/100000000000000000000}
C6_1 n6 n7 {18522911640650383000/3140955158567581}
R7_0 n7 n8 {21271613104837983/50000000000000000000}
C7_1 n7 n8 {7833405577259055000/7090537701612661}
R8_0 n8 n9 {2073045140059211/5000000000000000000}
C8_1 n8 n9 {5962995420531071000/2073045140059211}
R9_0 n9 n10 {8018133906505149/10000000000000000000}
C9_1 n9 n10 {30261265069265284000/8018133906505149}
R10_0 n10 n11 {232308783979019/2500000000000000000}
C10_1 n10 n11 {1745126894003017500/21118980361729}
R11_0 n11 portn {82382252563427/10000000000000000}
C11_1 n11 portn {194837386830151900/82382252563427}
.ends NONAGON_POSITIVE_REAL
