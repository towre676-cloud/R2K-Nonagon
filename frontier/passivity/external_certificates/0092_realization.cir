* Exact decimal-rational passive realization; s=+i*2*pi*f_hz
.subckt NONAGON_POSITIVE_REAL portp portn
R0_0 portp n1 {3414380446675957/250000000000000000}
L1_0 n1 n2 {9303148924487207/100000000000000000000000}
R2_0 n2 n3 {4004431843450369/2500000000000000000}
C2_1 n2 n3 {2735023091892717/16017727373801476}
R3_0 n3 n4 {11564262627923037/10000000000000000000}
C3_1 n3 n4 {6939906281779079/11564262627923037}
R4_0 n4 n5 {1825223411434883/2000000000000000000}
C4_1 n4 n5 {3521893423323676/1825223411434883}
R5_0 n5 n6 {533196471013629/2000000000000000000}
C5_1 n5 n6 {8936527945497550/533196471013629}
R6_0 n6 n7 {6006610166294299/50000000000000000000}
C6_1 n6 n7 {566893444246332850/6006610166294299}
R7_0 n7 n8 {215445483145853/6250000000000000000}
C7_1 n7 n8 {179805948736155525/215445483145853}
R8_0 n8 n9 {18343985382790899/100000000000000000000}
C8_1 n8 n9 {561530427837421000/1411075798676223}
R9_0 n9 n10 {355093350096019/5000000000000000000}
C9_1 n9 n10 {926145582032519150/355093350096019}
R10_0 n10 n11 {531894369038383/1250000000000000000}
C10_1 n10 n11 {587505418294429125/531894369038383}
R11_0 n11 n12 {539789729000591/1000000000000000000}
C11_1 n11 n12 {1192599084106214200/539789729000591}
R12_0 n12 n13 {4011612288261117/1000000000000000000}
C12_1 n12 n13 {2559519444537759000/1337204096087039}
R13_0 n13 portn {587571707364317/312500000000000000}
C13_1 n13 portn {6088668338442246875/587571707364317}
.ends NONAGON_POSITIVE_REAL
