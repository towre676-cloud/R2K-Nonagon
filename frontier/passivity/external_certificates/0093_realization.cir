* Exact decimal-rational passive realization; s=+i*2*pi*f_hz
.subckt NONAGON_POSITIVE_REAL portp portn
R0_0 portp n1 {13614110572360427/1000000000000000000}
L1_0 n1 n2 {4670559660170347/50000000000000000000000}
R2_0 n2 n3 {17658237450769007/10000000000000000000}
C2_1 n2 n3 {2735023091892717/17658237450769007}
R3_0 n3 n4 {9150913219541129/10000000000000000000}
C3_1 n3 n4 {6939906281779079/9150913219541129}
R4_0 n4 n5 {10975094276580559/10000000000000000000}
C4_1 n4 n5 {17609467116618380/10975094276580559}
R5_0 n5 n6 {8710164847253487/50000000000000000000}
C5_1 n5 n6 {223413198637438750/8710164847253487}
R6_0 n6 n7 {849298488295117/5000000000000000000}
C6_1 n6 n7 {56689344424633285/849298488295117}
R7_0 n7 n8 {4745096574650447/25000000000000000000}
C7_1 n7 n8 {1824973890471618250/4745096574650447}
R8_0 n8 n9 {3349051822082003/25000000000000000000}
C8_1 n8 n9 {4630727910162595750/3349051822082003}
R9_0 n9 n10 {1433789849441501/5000000000000000000}
C9_1 n9 n10 {2350021673177716500/1433789849441501}
R10_0 n10 n11 {1397953413254709/2000000000000000000}
C10_1 n10 n11 {2385198168212428400/1397953413254709}
R11_0 n11 n12 {3469913333673417/1000000000000000000}
C11_1 n11 n12 {853173148179253000/385545925963713}
R12_0 n12 portn {1132538427193501/400000000000000000}
C12_1 n12 portn {7793495473206076000/1132538427193501}
.ends NONAGON_POSITIVE_REAL
