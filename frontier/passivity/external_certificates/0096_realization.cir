* Exact decimal-rational passive realization; s=+i*2*pi*f_hz
.subckt NONAGON_POSITIVE_REAL portp portn
R0_0 portp n1 {217602062284481/15625000000000000}
L1_0 n1 n2 {9371295798190591/100000000000000000000000}
R2_0 n2 n3 {1443029982822503/1000000000000000000}
C2_1 n2 n3 {2735023091892717/14430299828225030}
R3_0 n3 n4 {1413113738412129/1000000000000000000}
C3_1 n3 n4 {6939906281779079/14131137384121290}
R4_0 n4 n5 {3899301335143909/5000000000000000000}
C4_1 n4 n5 {8804733558309190/3899301335143909}
R5_0 n5 n6 {2153065377047687/5000000000000000000}
C5_1 n5 n6 {22341319863743875/2153065377047687}
R6_0 n6 n7 {1159713404995991/100000000000000000000}
C6_1 n6 n7 {1133786888492665700/1159713404995991}
R7_0 n7 n8 {655193596626663/5000000000000000000}
C7_1 n7 n8 {47948252996308140/218397865542221}
R8_0 n8 n9 {1932836918688189/20000000000000000000}
C8_1 n8 n9 {1459979112377294600/1932836918688189}
R9_0 n9 n10 {759283407158171/6250000000000000000}
C9_1 n9 n10 {2315363955081297875/1518566814316342}
R10_0 n10 n11 {3658817948933937/10000000000000000000}
C10_1 n10 n11 {1566681115451811000/1219605982977979}
R11_0 n11 n12 {5713366601415587/10000000000000000000}
C11_1 n11 n12 {11925990841062142000/5713366601415587}
R12_0 n12 n13 {3902069168581573/1000000000000000000}
C12_1 n12 n13 {698050757601207000/354733560780143}
R13_0 n13 portn {1018144707341809/500000000000000000}
C13_1 n13 portn {9741869341507595000/1018144707341809}
.ends NONAGON_POSITIVE_REAL
