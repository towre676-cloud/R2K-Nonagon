* Exact decimal-rational passive realization; s=+i*2*pi*f_hz
.subckt NONAGON_POSITIVE_REAL portp portn
R0_0 portp n1 {6940391277606763/500000000000000000}
L1_0 n1 n2 {587201776960643/6250000000000000000000}
R2_0 n2 n3 {252409311956949/156250000000000000}
C2_1 n2 n3 {911674363964239/5384731988414912}
R3_0 n3 n4 {2330092006324691/2000000000000000000}
C3_1 n3 n4 {141630740444471/237764490441295}
R4_0 n4 n5 {9588298408637091/10000000000000000000}
C4_1 n4 n5 {17609467116618380/9588298408637091}
R5_0 n5 n6 {3596694656692157/10000000000000000000}
C5_1 n5 n6 {44682639727487750/3596694656692157}
R6_0 n6 n7 {1851649121959321/50000000000000000000}
C6_1 n6 n7 {566893444246332850/1851649121959321}
R7_0 n7 n8 {2320031409938027/20000000000000000000}
C7_1 n7 n8 {575379035955697680/2320031409938027}
R8_0 n8 n9 {482716090607323/6250000000000000000}
C8_1 n8 n9 {912486945235809125/965432181214646}
R9_0 n9 n10 {10286436114393973/50000000000000000000}
C9_1 n9 n10 {9261455820325191500/10286436114393973}
R10_0 n10 n11 {2279106534768543/10000000000000000000}
C10_1 n10 n11 {522227038483937000/253234059418727}
R11_0 n11 n12 {1789949788848781/2500000000000000000}
C11_1 n11 n12 {2981497710265535500/1789949788848781}
R12_0 n12 n13 {17149054348476803/5000000000000000000}
C12_1 n12 n13 {38392791668066385000/17149054348476803}
R13_0 n13 portn {1423607115235059/500000000000000000}
C13_1 n13 portn {9741869341507595000/1423607115235059}
.ends NONAGON_POSITIVE_REAL
