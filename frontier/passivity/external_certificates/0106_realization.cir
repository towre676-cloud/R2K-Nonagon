* Exact decimal-rational passive realization; s=+i*2*pi*f_hz
.subckt NONAGON_POSITIVE_REAL portp portn
R0_0 portp n1 {3473548206592911/250000000000000000}
L1_0 n1 n2 {9438717278273917/100000000000000000000000}
R2_0 n2 n3 {1015502582655499/625000000000000000}
C2_1 n2 n3 {2735023091892717/16248041322487984}
R3_0 n3 n4 {2314499921494983/2000000000000000000}
C3_1 n3 n4 {6939906281779079/11572499607474915}
R4_0 n4 n5 {9047467732723/7812500000000000}
C4_1 n4 n5 {880473355830919/579037934894272}
R5_0 n5 n6 {12082916608859411/25000000000000000000}
C5_1 n5 n6 {111706599318719375/12082916608859411}
R6_0 n6 n7 {921576088372669/5000000000000000000}
C6_1 n6 n7 {364994778094323650/921576088372669}
R7_0 n7 n8 {5522883757670609/50000000000000000000}
C7_1 n7 n8 {9261455820325191500/5522883757670609}
R8_0 n8 n9 {3001421785053401/10000000000000000000}
C8_1 n8 n9 {4700043346355433000/3001421785053401}
R9_0 n9 n10 {3279228622481827/5000000000000000000}
C9_1 n9 n10 {5962995420531071000/3279228622481827}
R10_0 n10 n11 {4021167254634417/1250000000000000000}
C10_1 n10 n11 {3199399305672198750/1340389084878139}
R11_0 n11 portn {110652742248871/31250000000000000}
C11_1 n11 portn {1217733667688449375/221305484497742}
.ends NONAGON_POSITIVE_REAL
