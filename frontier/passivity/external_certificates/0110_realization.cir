* Exact decimal-rational passive realization; s=+i*2*pi*f_hz
.subckt NONAGON_POSITIVE_REAL portp portn
R0_0 portp n1 {2719970372766907/200000000000000000}
L1_0 n1 n2 {4568453247992733/50000000000000000000000}
R2_0 n2 n3 {989415647136723/500000000000000000}
C2_1 n2 n3 {911674363964239/6596104314244820}
R3_0 n3 n4 {890829781167313/1250000000000000000}
C3_1 n3 n4 {6939906281779079/7126638249338504}
R4_0 n4 n5 {16634503645735813/10000000000000000000}
C4_1 n4 n5 {88489784505620/83590470581587}
R5_0 n5 n6 {1776285111475921/5000000000000000000}
C5_1 n5 n6 {22341319863743875/1776285111475921}
R6_0 n6 n7 {10953334700725599/50000000000000000000}
C6_1 n6 n7 {40109316274101500/120366315392589}
R7_0 n7 n8 {2654547130912549/25000000000000000000}
C7_1 n7 n8 {4630727910162595750/2654547130912549}
R8_0 n8 n9 {1580193196895657/5000000000000000000}
C8_1 n8 n9 {2350021673177716500/1580193196895657}
R9_0 n9 n10 {171506951759173/250000000000000000}
C9_1 n9 n10 {298149771026553550/171506951759173}
R10_0 n10 n11 {6832619128492169/2500000000000000000}
C10_1 n10 n11 {19196395834033192500/6832619128492169}
R11_0 n11 portn {4669335357933137/1000000000000000000}
C11_1 n11 portn {19483738683015190000/4669335357933137}
.ends NONAGON_POSITIVE_REAL
