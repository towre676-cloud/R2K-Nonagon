* Exact decimal-rational passive realization; s=+i*2*pi*f_hz
.subckt NONAGON_POSITIVE_REAL portp portn
R0_0 portp n1 {13599720114792501/1000000000000000000}
L1_0 n1 n2 {1897656796304329/20000000000000000000000}
R2_0 n2 n3 {4545160952205591/5000000000000000000}
C2_1 n2 n3 {7780490169904571/30301073014703940}
R3_0 n3 n4 {7590145364667119/5000000000000000000}
C3_1 n3 n4 {7362960384621947/30360581458668476}
R4_0 n4 n5 {387990108080553/250000000000000000}
C4_1 n4 n5 {3611147618308567/3879901080805530}
R5_0 n5 n6 {6137851932645457/50000000000000000000}
C5_1 n5 n6 {113912004153991885/6137851932645457}
R6_0 n6 n7 {153905622123763/400000000000000000}
C6_1 n6 n7 {56674539326660636/3847640553094075}
R7_0 n7 n8 {6324517062314389/100000000000000000000}
C7_1 n7 n8 {2223672186373870700/6324517062314389}
R8_0 n8 n9 {1167908186687099/12500000000000000000}
C8_1 n8 n9 {1382927086045728125/2335816373374198}
R9_0 n9 n10 {67516033679241/625000000000000000}
C9_1 n9 n10 {218119020074974975/270064134716964}
R10_0 n10 n11 {37127793646941947/100000000000000000000}
C10_1 n10 n11 {34232316946716280000/37127793646941947}
R11_0 n11 n12 {977555876432041/1250000000000000000}
C11_1 n11 n12 {1678916405275020500/977555876432041}
R12_0 n12 n13 {4492884396993543/2000000000000000000}
C12_1 n12 n13 {5541212701893238000/1497628132331181}
R13_0 n13 portn {3909361803461893/1000000000000000000}
C13_1 n13 portn {13109627001592970000/3909361803461893}
.ends NONAGON_POSITIVE_REAL
