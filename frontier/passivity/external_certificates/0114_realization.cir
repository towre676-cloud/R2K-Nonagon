* Exact decimal-rational passive realization; s=+i*2*pi*f_hz
.subckt NONAGON_POSITIVE_REAL portp portn
R0_0 portp n1 {16999229197861/1250000000000000}
L1_0 n1 n2 {9470572492980123/100000000000000000000000}
R2_0 n2 n3 {2014400964322783/1000000000000000000}
C2_1 n2 n3 {2735023091892717/20144009643227830}
R3_0 n3 n4 {93142667973771/156250000000000000}
C3_1 n3 n4 {6939906281779079/5961130750321344}
R4_0 n4 n5 {17550672486937103/10000000000000000000}
C4_1 n4 n5 {17609467116618380/17550672486937103}
R5_0 n5 n6 {8063910601806077/50000000000000000000}
C5_1 n5 n6 {223413198637438750/8063910601806077}
R6_0 n6 n7 {4139234684747157/1000000000000000000000}
C6_1 n6 n7 {9589650599261628000/1379744894915719}
R7_0 n7 n8 {2829204034182623/12500000000000000000}
C7_1 n7 n8 {912486945235809125/2829204034182623}
R8_0 n8 n9 {1986625249930353/25000000000000000000}
C8_1 n8 n9 {4630727910162595750/1986625249930353}
R9_0 n9 n10 {33670007008462067/100000000000000000000}
C9_1 n9 n10 {47000433463554330000/33670007008462067}
R10_0 n10 n11 {6340249183816543/10000000000000000000}
C10_1 n10 n11 {11925990841062142000/6340249183816543}
R11_0 n11 n12 {31947297922881577/10000000000000000000}
C11_1 n11 n12 {76785583336132770000/31947297922881577}
R12_0 n12 portn {1135555186036047/312500000000000000}
C12_1 n12 portn {6088668338442246875/1135555186036047}
.ends NONAGON_POSITIVE_REAL
