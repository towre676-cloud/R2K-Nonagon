* Exact decimal-rational passive realization; s=+i*2*pi*f_hz
.subckt NONAGON_POSITIVE_REAL portp portn
R0_0 portp n1 {866920046116877/62500000000000000}
L1_0 n1 n2 {4628190886876903/50000000000000000000000}
R2_0 n2 n3 {3018311620664607/2000000000000000000}
C2_1 n2 n3 {911674363964239/5030519367774345}
R3_0 n3 n4 {1388228944943813/1000000000000000000}
C3_1 n3 n4 {141630740444471/283312029580370}
R4_0 n4 n5 {567113124466513/625000000000000000}
C4_1 n4 n5 {4402366779154595/2268452497866052}
R5_0 n5 n6 {1693208502143891/4000000000000000000}
C5_1 n5 n6 {17873055890995100/1693208502143891}
R6_0 n6 n7 {1687800210652481/25000000000000000000}
C6_1 n6 n7 {283446722123166425/1687800210652481}
R7_0 n7 n8 {10982263103020719/100000000000000000000}
C7_1 n7 n8 {319655019975387600/1220251455891191}
R8_0 n8 n9 {841192571788919/10000000000000000000}
C8_1 n8 n9 {104284222312663900/120170367398417}
R9_0 n9 n10 {3459384346180139/20000000000000000000}
C9_1 n9 n10 {3704582328130076600/3459384346180139}
R10_0 n10 n11 {30603451680069973/100000000000000000000}
C10_1 n10 n11 {47000433463554330000/30603451680069973}
R11_0 n11 n12 {3080447687090177/5000000000000000000}
C11_1 n11 n12 {5962995420531071000/3080447687090177}
R12_0 n12 n13 {33303747595898113/10000000000000000000}
C12_1 n12 n13 {76785583336132770000/33303747595898113}
R13_0 n13 portn {2075192686362729/625000000000000000}
C13_1 n13 portn {12177336676884493750/2075192686362729}
.ends NONAGON_POSITIVE_REAL
