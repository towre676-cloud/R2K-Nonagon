* Exact decimal-rational passive realization; s=+i*2*pi*f_hz
.subckt NONAGON_POSITIVE_REAL portp portn
R0_0 portp n1 {13828320017465581/1000000000000000000}
L1_0 n1 n2 {9293800917451351/100000000000000000000000}
R2_0 n2 n3 {834729223694449/500000000000000000}
C2_1 n2 n3 {2735023091892717/16694584473888980}
R3_0 n3 n4 {5788936939831813/5000000000000000000}
C3_1 n3 n4 {6939906281779079/11577873879663626}
R4_0 n4 n5 {5333424276255561/5000000000000000000}
C4_1 n4 n5 {8804733558309190/5333424276255561}
R5_0 n5 n6 {1855255853673111/5000000000000000000}
C5_1 n5 n6 {22341319863743875/1855255853673111}
R6_0 n6 n7 {4593362001061631/50000000000000000000}
C6_1 n6 n7 {566893444246332850/4593362001061631}
R7_0 n7 n8 {1536871333800097/25000000000000000000}
C7_1 n7 n8 {719223794944622100/1536871333800097}
R8_0 n8 n9 {259148051658603/2000000000000000000}
C8_1 n8 n9 {145997911237729460/259148051658603}
R9_0 n9 n10 {224308561706473/1250000000000000000}
C9_1 n9 n10 {463072791016259575/448617123412946}
R10_0 n10 n11 {11706077636740329/50000000000000000000}
C10_1 n10 n11 {7833405577259055000/3902025878913443}
R11_0 n11 n12 {359930319514249/500000000000000000}
C11_1 n11 n12 {596299542053107100/359930319514249}
R12_0 n12 n13 {2954537907419783/1000000000000000000}
C12_1 n12 n13 {7678558333613277000/2954537907419783}
R13_0 n13 portn {248697064292587/62500000000000000}
C13_1 n13 portn {1217733667688449375/248697064292587}
.ends NONAGON_POSITIVE_REAL
