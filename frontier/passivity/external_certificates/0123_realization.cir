* Exact decimal-rational passive realization; s=+i*2*pi*f_hz
.subckt NONAGON_POSITIVE_REAL portp portn
R0_0 portp n1 {6902073877453589/500000000000000000}
L1_0 n1 n2 {931927589194349/10000000000000000000000}
R2_0 n2 n3 {868296972492771/500000000000000000}
C2_1 n2 n3 {911674363964239/5788646483285140}
R3_0 n3 n4 {10425330336269567/10000000000000000000}
C3_1 n3 n4 {6939906281779079/10425330336269567}
R4_0 n4 n5 {2991037222068837/2500000000000000000}
C4_1 n4 n5 {4402366779154595/2991037222068837}
R5_0 n5 n6 {43571542099378897/100000000000000000000}
C5_1 n5 n6 {446826397274877500/43571542099378897}
R6_0 n6 n7 {20602381558408923/100000000000000000000}
C6_1 n6 n7 {80218632548203000/226399797345153}
R7_0 n7 n8 {5058897186593907/50000000000000000000}
C7_1 n7 n8 {9261455820325191500/5058897186593907}
R8_0 n8 n9 {29323188094972037/100000000000000000000}
C8_1 n8 n9 {47000433463554330000/29323188094972037}
R9_0 n9 n10 {1742145560776897/2500000000000000000}
C9_1 n9 n10 {2981497710265535500/1742145560776897}
R10_0 n10 n11 {2889801267059/1000000000000000}
C10_1 n10 n11 {7678558333613277/2889801267059}
R11_0 n11 portn {4139223744319667/1000000000000000000}
C11_1 n11 portn {19483738683015190000/4139223744319667}
.ends NONAGON_POSITIVE_REAL
