* Exact decimal-rational passive realization; s=+i*2*pi*f_hz
.subckt NONAGON_POSITIVE_REAL portp portn
R0_0 portp n1 {6903517564897747/500000000000000000}
L1_0 n1 n2 {1156270192660267/12500000000000000000000}
R2_0 n2 n3 {3793882139474371/2500000000000000000}
C2_1 n2 n3 {2735023091892717/15175528557897484}
R3_0 n3 n4 {3535048562875517/2500000000000000000}
C3_1 n3 n4 {6939906281779079/14140194251502068}
R4_0 n4 n5 {9184082391904711/10000000000000000000}
C4_1 n4 n5 {17609467116618380/9184082391904711}
R5_0 n5 n6 {48473078056273527/100000000000000000000}
C5_1 n5 n6 {446826397274877500/48473078056273527}
R6_0 n6 n7 {3016422733946889/25000000000000000000}
C6_1 n6 n7 {239741264981540700/1005474244648963}
R7_0 n7 n8 {6427963957121791/100000000000000000000}
C7_1 n7 n8 {1042842223126639000/918280565303113}
R8_0 n8 n9 {17295995892929/97656250000000000}
C8_1 n8 n9 {2315363955081297875/2213887474294912}
R9_0 n9 n10 {13495717703222143/50000000000000000000}
C9_1 n9 n10 {23500216731777165000/13495717703222143}
R10_0 n10 n11 {1314776635703347/2000000000000000000}
C10_1 n10 n11 {2385198168212428400/1314776635703347}
R11_0 n11 n12 {768516292387363/250000000000000000}
C11_1 n11 n12 {1919639583403319250/768516292387363}
R12_0 n12 portn {961104937410029/250000000000000000}
C12_1 n12 portn {4870934670753797500/961104937410029}
.ends NONAGON_POSITIVE_REAL
