* Exact decimal-rational passive realization; s=+i*2*pi*f_hz
.subckt NONAGON_POSITIVE_REAL portp portn
R0_0 portp n1 {13762614198153179/1000000000000000000}
L1_0 n1 n2 {4644200592987343/50000000000000000000000}
R2_0 n2 n3 {4225595508852399/2500000000000000000}
C2_1 n2 n3 {911674363964239/5634127345136532}
R3_0 n3 n4 {5758975956345053/5000000000000000000}
C3_1 n3 n4 {6939906281779079/11517951912690106}
R4_0 n4 n5 {1141096955666663/1000000000000000000}
C4_1 n4 n5 {1760946711661838/1141096955666663}
R5_0 n5 n6 {1813589080582951/5000000000000000000}
C5_1 n5 n6 {22341319863743875/1813589080582951}
R6_0 n6 n7 {4116821819541847/100000000000000000000}
C6_1 n6 n7 {1133786888492665700/4116821819541847}
R7_0 n7 n8 {171765802309541/1562500000000000000}
C7_1 n7 n8 {179805948736155525/687063209238164}
R8_0 n8 n9 {1427750181631219/20000000000000000000}
C8_1 n8 n9 {1459979112377294600/1427750181631219}
R9_0 n9 n10 {9156058012406097/50000000000000000000}
C9_1 n9 n10 {9261455820325191500/9156058012406097}
R10_0 n10 n11 {2256065342804191/10000000000000000000}
C10_1 n10 n11 {4700043346355433000/2256065342804191}
R11_0 n11 n12 {3633289154394029/5000000000000000000}
C11_1 n11 n12 {458691955425467000/279483781107233}
R12_0 n12 n13 {28321066496065357/10000000000000000000}
C12_1 n12 n13 {76785583336132770000/28321066496065357}
R13_0 n13 portn {4263605110221769/1000000000000000000}
C13_1 n13 portn {19483738683015190000/4263605110221769}
.ends NONAGON_POSITIVE_REAL
