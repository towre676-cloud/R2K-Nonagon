* Exact decimal-rational passive realization; s=+i*2*pi*f_hz
.subckt NONAGON_POSITIVE_REAL portp portn
R0_0 portp n1 {6811029812034983/500000000000000000}
L1_0 n1 n2 {9007440831691383/100000000000000000000000}
R2_0 n2 n3 {18134787222186513/10000000000000000000}
C2_1 n2 n3 {911674363964239/6044929074062171}
R3_0 n3 n4 {10577216785001209/10000000000000000000}
C3_1 n3 n4 {141630740444471/215861567040841}
R4_0 n4 n5 {12664323089145307/10000000000000000000}
C4_1 n4 n5 {17609467116618380/12664323089145307}
R5_0 n5 n6 {7083358325327229/25000000000000000000}
C5_1 n5 n6 {111706599318719375/7083358325327229}
R6_0 n6 n7 {209185640151373/1250000000000000000}
C6_1 n6 n7 {56689344424633285/836742560605492}
R7_0 n7 n8 {4227187397751731/100000000000000000000}
C7_1 n7 n8 {410985025682641200/603883913964533}
R8_0 n8 n9 {12160590588483901/100000000000000000000}
C8_1 n8 n9 {7299895561886473000/12160590588483901}
R9_0 n9 n10 {4959161404534511/25000000000000000000}
C9_1 n9 n10 {4630727910162595750/4959161404534511}
R10_0 n10 n11 {1925266170179307/10000000000000000000}
C10_1 n10 n11 {1566681115451811000/641755390059769}
R11_0 n11 n12 {506373644744199/625000000000000000}
C11_1 n11 n12 {745374427566383875/506373644744199}
R12_0 n12 n13 {12324345283409167/10000000000000000000}
C12_1 n12 n13 {76785583336132770000/12324345283409167}
R13_0 n13 portn {3900975944494123/500000000000000000}
C13_1 n13 portn {9741869341507595000/3900975944494123}
.ends NONAGON_POSITIVE_REAL
