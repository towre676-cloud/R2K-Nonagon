* Exact decimal-rational passive realization; s=+i*2*pi*f_hz
.subckt NONAGON_POSITIVE_REAL portp portn
R0_0 portp n1 {1350750035037709/100000000000000000}
L1_0 n1 n2 {2327555928220897/25000000000000000000000}
R2_0 n2 n3 {1162489939838431/625000000000000000}
C2_1 n2 n3 {2735023091892717/18599839037414896}
R3_0 n3 n4 {7626388624750167/10000000000000000000}
C3_1 n3 n4 {6939906281779079/7626388624750167}
R4_0 n4 n5 {1633284896196961/1000000000000000000}
C4_1 n4 n5 {1760946711661838/1633284896196961}
R5_0 n5 n6 {364633097510919/3125000000000000000}
C5_1 n5 n6 {59935316245385175/243088731673946}
R6_0 n6 n7 {6668162692586553/50000000000000000000}
C6_1 n6 n7 {3649947780943236500/6668162692586553}
R7_0 n7 n8 {27112938430953433/500000000000000000000}
C7_1 n7 n8 {92614558203251915000/27112938430953433}
R8_0 n8 n9 {11112667452698099/25000000000000000000}
C8_1 n8 n9 {11750108365888582500/11112667452698099}
R9_0 n9 n10 {25551370953956243/100000000000000000000}
C9_1 n9 n10 {119259908410621420000/25551370953956243}
R10_0 n10 n11 {1165225849025363/1000000000000000000}
C10_1 n10 n11 {3026126506926528400/1165225849025363}
R11_0 n11 n12 {14393918775265923/1000000000000000000}
C11_1 n11 n12 {49438456618377490000/14393918775265923}
R12_0 n12 portn {1169713678799213/100000000000000000}
C12_1 n12 portn {12544620067902484000/1169713678799213}
.ends NONAGON_POSITIVE_REAL
