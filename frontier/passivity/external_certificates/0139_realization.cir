* Exact decimal-rational passive realization; s=+i*2*pi*f_hz
.subckt NONAGON_POSITIVE_REAL portp portn
R0_0 portp n1 {13623780627114883/1000000000000000000}
L1_0 n1 n2 {2338553840511291/25000000000000000000000}
R2_0 n2 n3 {3659239389442833/2000000000000000000}
C2_1 n2 n3 {911674363964239/6098732315738055}
R3_0 n3 n4 {2157197427957011/2500000000000000000}
C3_1 n3 n4 {6939906281779079/8628789711828044}
R4_0 n4 n5 {3683722276022657/2500000000000000000}
C4_1 n4 n5 {4402366779154595/3683722276022657}
R5_0 n5 n6 {4680497260458733/100000000000000000000}
C5_1 n5 n6 {14413754750802500/150983782595443}
R6_0 n6 n7 {279638121970657/2000000000000000000}
C6_1 n6 n7 {57537903595569768/279638121970657}
R7_0 n7 n8 {4509879246576483/50000000000000000000}
C7_1 n7 n8 {280765213918710500/346913788198191}
R8_0 n8 n9 {7376074654996567/50000000000000000000}
C8_1 n8 n9 {9261455820325191500/7376074654996567}
R9_0 n9 n10 {3885805810801347/12500000000000000000}
C9_1 n9 n10 {1958351394314763750/1295268603600449}
R10_0 n10 n11 {1047065056690031/2000000000000000000}
C10_1 n10 n11 {2385198168212428400/1047065056690031}
R11_0 n11 n12 {6898735702460623/10000000000000000000}
C11_1 n11 n12 {30261265069265284000/6898735702460623}
R12_0 n12 n13 {9121730611496749/10000000000000000000}
C12_1 n12 n13 {76785583336132770000/9121730611496749}
R13_0 n13 n14 {9805837539270517/1000000000000000000}
C13_1 n13 n14 {49438456618377490000/9805837539270517}
R14_0 n14 portn {17427475936584627/1000000000000000000}
C14_1 n14 portn {125446200679024840000/17427475936584627}
.ends NONAGON_POSITIVE_REAL
