* Exact decimal-rational passive realization; s=+i*2*pi*f_hz
.subckt NONAGON_POSITIVE_REAL portp portn
R0_0 portp n1 {6568699321103869/500000000000000000}
L1_0 n1 n2 {4529298098033129/50000000000000000000000}
C2_0 n2 n3 {1000000000000000000/334896331501797}
R3_0 n3 n4 {12415327883954009/10000000000000000000}
C3_1 n3 n4 {3334495787101959/17736182691362870}
R4_0 n4 n5 {11449314003371051/10000000000000000000}
C4_1 n4 n5 {7362960384621947/22898628006742102}
R5_0 n5 n6 {838480050859679/500000000000000000}
C5_1 n5 n6 {3611147618308567/4192400254298395}
R6_0 n6 n7 {342036827760247/1250000000000000000}
C6_1 n6 n7 {22782400830798377/2736294622081976}
R7_0 n7 n8 {10534697255758399/50000000000000000000}
C7_1 n7 n8 {1753618116074005500/10534697255758399}
R8_0 n8 n9 {4943194663111263/25000000000000000000}
C8_1 n8 n9 {602892024366680000/549243851456807}
R9_0 n9 n10 {4614935097391681/100000000000000000000}
C9_1 n9 n10 {34232316946716280000/4614935097391681}
R10_0 n10 n11 {10384371682064057/100000000000000000000}
C10_1 n10 n11 {53992141036615850000/10384371682064057}
R11_0 n11 n12 {1247990258969979/2500000000000000000}
C11_1 n11 n12 {709648940370037250/415996752989993}
R12_0 n12 n13 {10689358563642393/10000000000000000000}
C12_1 n12 n13 {33412392150805780000/10689358563642393}
R13_0 n13 portn {5655519977905337/12500000000000000000}
C13_1 n13 portn {65873666694289700000/5655519977905337}
.ends NONAGON_POSITIVE_REAL
