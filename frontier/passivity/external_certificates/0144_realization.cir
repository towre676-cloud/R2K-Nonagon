* Exact decimal-rational passive realization; s=+i*2*pi*f_hz
.subckt NONAGON_POSITIVE_REAL portp portn
R0_0 portp n1 {13600113963529907/1000000000000000000}
L1_0 n1 n2 {928400974860377/10000000000000000000000}
C2_0 n2 n3 {10000000000000000000/3651811023297821}
R3_0 n3 n4 {166542858072323/100000000000000000}
C3_1 n3 n4 {2735023091892717/16654285807232300}
R4_0 n4 n5 {11439053221952457/10000000000000000000}
C4_1 n4 n5 {6939906281779079/11439053221952457}
R5_0 n5 n6 {8821373879041909/10000000000000000000}
C5_1 n5 n6 {17609467116618380/8821373879041909}
R6_0 n6 n7 {1523595760664473/5000000000000000000}
C6_1 n6 n7 {22341319863743875/1523595760664473}
R7_0 n7 n8 {2378160589840439/50000000000000000000}
C7_1 n7 n8 {566893444246332850/2378160589840439}
R8_0 n8 n9 {2539367900055879/125000000000000000000}
C8_1 n8 n9 {1198706324907703500/846455966685293}
R9_0 n9 n10 {7679492455325039/50000000000000000000}
C9_1 n9 n10 {3649947780943236500/7679492455325039}
R10_0 n10 n11 {27603171714910777/500000000000000000000}
C10_1 n10 n11 {92614558203251915000/27603171714910777}
R11_0 n11 n12 {4208610163089149/10000000000000000000}
C11_1 n11 n12 {4700043346355433000/4208610163089149}
R12_0 n12 n13 {441622294959431/1562500000000000000}
C12_1 n12 n13 {3726872137831919375/883244589918862}
R13_0 n13 portn {1242877975246339/1000000000000000000}
C13_1 n13 portn {3026126506926528400/1242877975246339}
.ends NONAGON_POSITIVE_REAL
