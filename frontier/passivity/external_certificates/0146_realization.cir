* Exact decimal-rational passive realization; s=+i*2*pi*f_hz
.subckt NONAGON_POSITIVE_REAL portp portn
R0_0 portp n1 {6783883846298089/500000000000000000}
L1_0 n1 n2 {4657303823218359/50000000000000000000000}
C2_0 n2 n3 {2000000000000000000/721658980786923}
R3_0 n3 n4 {4552812457768761/2500000000000000000}
C3_1 n3 n4 {911674363964239/6070416610358348}
R4_0 n4 n5 {498912587937593/625000000000000000}
C4_1 n4 n5 {6939906281779079/7982601407001488}
R5_0 n5 n6 {14266785928025707/10000000000000000000}
C5_1 n5 n6 {17609467116618380/14266785928025707}
R6_0 n6 n7 {313382297293291/20000000000000000000}
C6_1 n6 n7 {575379035955697680/313382297293291}
R7_0 n7 n8 {21470219626853579/100000000000000000000}
C7_1 n7 n8 {7299895561886473000/21470219626853579}
R8_0 n8 n9 {155478852447567/312500000000000000}
C8_1 n8 n9 {195835139431476375/207305136596756}
R9_0 n9 n10 {18474231223773483/100000000000000000000}
C9_1 n9 n10 {119259908410621420000/18474231223773483}
R10_0 n10 portn {13171575747631787/10000000000000000000}
C10_1 n10 portn {30261265069265284000/13171575747631787}
.ends NONAGON_POSITIVE_REAL
