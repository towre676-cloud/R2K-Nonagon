* Exact decimal-rational passive realization; s=+i*2*pi*f_hz
.subckt NONAGON_POSITIVE_REAL portp portn
R0_0 portp n1 {13648825368591869/1000000000000000000}
L1_0 n1 n2 {1137146143372957/12500000000000000000000}
C2_0 n2 n3 {100000000000000000/37488120634253}
R3_0 n3 n4 {3603573726489821/2000000000000000000}
C3_1 n3 n4 {2735023091892717/18017868632449105}
R4_0 n4 n5 {9837777136180493/10000000000000000000}
C4_1 n4 n5 {6939906281779079/9837777136180493}
R5_0 n5 n6 {10673071581680797/10000000000000000000}
C5_1 n5 n6 {17609467116618380/10673071581680797}
R6_0 n6 n7 {4319382749210029/25000000000000000000}
C6_1 n6 n7 {111706599318719375/4319382749210029}
R7_0 n7 n8 {13115514664736617/100000000000000000000}
C7_1 n7 n8 {1133786888492665700/13115514664736617}
R8_0 n8 n9 {16181597206691453/100000000000000000000}
C8_1 n8 n9 {7299895561886473000/16181597206691453}
R9_0 n9 n10 {4805839126492533/50000000000000000000}
C9_1 n9 n10 {9261455820325191500/4805839126492533}
R10_0 n10 n11 {7726079399982609/20000000000000000000}
C10_1 n10 n11 {3133362230903622000/2575359799994203}
R11_0 n11 n12 {34680376711146297/100000000000000000000}
C11_1 n11 n12 {119259908410621420000/34680376711146297}
R12_0 n12 portn {5974547707764873/5000000000000000000}
C12_1 n12 portn {15130632534632642000/5974547707764873}
.ends NONAGON_POSITIVE_REAL
