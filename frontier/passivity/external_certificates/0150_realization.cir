* Exact decimal-rational passive realization; s=+i*2*pi*f_hz
.subckt NONAGON_POSITIVE_REAL portp portn
R0_0 portp n1 {6812272287615719/500000000000000000}
L1_0 n1 n2 {4563315876023701/50000000000000000000000}
C2_0 n2 n3 {12500000000000000000/4623333427704737}
R3_0 n3 n4 {9595293633003001/5000000000000000000}
C3_1 n3 n4 {2735023091892717/19190587266006002}
R4_0 n4 n5 {1395995982268141/2000000000000000000}
C4_1 n4 n5 {6939906281779079/6979979911340705}
R5_0 n5 n6 {1515020448281117/1000000000000000000}
C5_1 n5 n6 {1760946711661838/1515020448281117}
R6_0 n6 n7 {1335565122726579/250000000000000000000}
C6_1 n6 n7 {2397412649815407000/445188374242193}
R7_0 n7 n8 {5037692506859241/20000000000000000000}
C7_1 n7 n8 {1459979112377294600/5037692506859241}
R8_0 n8 n9 {48522010937476133/100000000000000000000}
C8_1 n8 n9 {47000433463554330000/48522010937476133}
R9_0 n9 n10 {313524261591017/1250000000000000000}
C9_1 n9 n10 {1490748855132767750/313524261591017}
R10_0 n10 n11 {6292054187826433/5000000000000000000}
C10_1 n10 n11 {15130632534632642000/6292054187826433}
R11_0 n11 portn {15367914149412347/1000000000000000000000}
C11_1 n11 portn {7678558333613277000000/15367914149412347}
.ends NONAGON_POSITIVE_REAL
