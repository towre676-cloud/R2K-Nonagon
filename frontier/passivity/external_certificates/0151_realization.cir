* Exact decimal-rational passive realization; s=+i*2*pi*f_hz
.subckt NONAGON_POSITIVE_REAL portp portn
R0_0 portp n1 {13593508733211543/1000000000000000000}
L1_0 n1 n2 {9158560771292701/100000000000000000000000}
C2_0 n2 n3 {100000000000000000000/35538191419733973}
R3_0 n3 n4 {994042151510137/500000000000000000}
C3_1 n3 n4 {2735023091892717/19880843030202740}
R4_0 n4 n5 {6402306561137577/10000000000000000000}
C4_1 n4 n5 {6939906281779079/6402306561137577}
R5_0 n5 n6 {3778221996735251/2500000000000000000}
C5_1 n5 n6 {4402366779154595/3778221996735251}
R6_0 n6 n7 {3249152188781413/50000000000000000000}
C6_1 n6 n7 {1438447589889244200/3249152188781413}
R7_0 n7 n8 {1792248618604399/10000000000000000000}
C7_1 n7 n8 {729989556188647300/1792248618604399}
R8_0 n8 n9 {5791732638896781/100000000000000000000}
C8_1 n8 n9 {18522911640650383000/5791732638896781}
R9_0 n9 n10 {23011097309522463/50000000000000000000}
C9_1 n9 n10 {7833405577259055000/7670365769840821}
R10_0 n10 n11 {1298232728475459/5000000000000000000}
C10_1 n10 n11 {5962995420531071000/1298232728475459}
R11_0 n11 n12 {5898473597969789/5000000000000000000}
C11_1 n11 n12 {15130632534632642000/5898473597969789}
R12_0 n12 portn {1271830836114791/5000000000000000000}
C12_1 n12 portn {38392791668066385000/1271830836114791}
.ends NONAGON_POSITIVE_REAL
