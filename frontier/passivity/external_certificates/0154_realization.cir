* Exact decimal-rational passive realization; s=+i*2*pi*f_hz
.subckt NONAGON_POSITIVE_REAL portp portn
R0_0 portp n1 {6783823944205753/500000000000000000}
L1_0 n1 n2 {584120963448861/6250000000000000000000}
C2_0 n2 n3 {10000000000000000000/3516890411008979}
R3_0 n3 n4 {8706951929780607/5000000000000000000}
C3_1 n3 n4 {911674363964239/5804634619853738}
R4_0 n4 n5 {8893617359391151/10000000000000000000}
C4_1 n4 n5 {6939906281779079/8893617359391151}
R5_0 n5 n6 {1678328764528539/1250000000000000000}
C5_1 n5 n6 {4402366779154595/3356657529057078}
R6_0 n6 n7 {310430367687063/1250000000000000000}
C6_1 n6 n7 {14038260695935525/47758518105702}
R7_0 n7 n8 {300481959803879/625000000000000000}
C7_1 n7 n8 {587505418294429125/600963919607758}
R8_0 n8 n9 {13519010118098797/50000000000000000000}
C8_1 n8 n9 {4586919554254670000/1039923855238369}
R9_0 n9 n10 {11765753435903923/10000000000000000000}
C9_1 n9 n10 {30261265069265284000/11765753435903923}
R10_0 n10 portn {2508341750158803/10000000000000000000}
C10_1 n10 portn {25595194445377590000/836113916719601}
.ends NONAGON_POSITIVE_REAL
