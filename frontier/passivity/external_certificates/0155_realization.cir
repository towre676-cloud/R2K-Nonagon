* Exact decimal-rational passive realization; s=+i*2*pi*f_hz
.subckt NONAGON_POSITIVE_REAL portp portn
R0_0 portp n1 {6767400200002897/500000000000000000}
L1_0 n1 n2 {375470001462463/4000000000000000000000}
C2_0 n2 n3 {800000000000000000/258845326243743}
R3_0 n3 n4 {1834285578534029/1000000000000000000}
C3_1 n3 n4 {2735023091892717/18342855785340290}
R4_0 n4 n5 {7826892519579221/10000000000000000000}
C4_1 n4 n5 {6939906281779079/7826892519579221}
R5_0 n5 n6 {678478894448877/500000000000000000}
C5_1 n5 n6 {880473355830919/678478894448877}
R6_0 n6 n7 {8544153210777563/100000000000000000000}
C6_1 n6 n7 {2876895179778488400/8544153210777563}
R7_0 n7 n8 {3793915045184503/25000000000000000000}
C7_1 n7 n8 {1824973890471618250/3793915045184503}
R8_0 n8 n9 {384219802327601/5000000000000000000}
C8_1 n8 n9 {926145582032519150/384219802327601}
R9_0 n9 n10 {40435614632954037/100000000000000000000}
C9_1 n9 n10 {15666811154518110000/13478538210984679}
R10_0 n10 n11 {3813923386046549/10000000000000000000}
C10_1 n10 n11 {11925990841062142000/3813923386046549}
R11_0 n11 n12 {2288969202676751/2500000000000000000}
C11_1 n11 n12 {7565316267316321000/2288969202676751}
R12_0 n12 portn {7938785496707149/10000000000000000000}
C12_1 n12 portn {76785583336132770000/7938785496707149}
.ends NONAGON_POSITIVE_REAL
