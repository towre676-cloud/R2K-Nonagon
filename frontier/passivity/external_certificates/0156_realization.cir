* Exact decimal-rational passive realization; s=+i*2*pi*f_hz
.subckt NONAGON_POSITIVE_REAL portp portn
R0_0 portp n1 {3421122913677817/250000000000000000}
L1_0 n1 n2 {4565206514390649/50000000000000000000000}
C2_0 n2 n3 {5000000000000000000/1681845009282901}
R3_0 n3 n4 {17541360729261993/10000000000000000000}
C3_1 n3 n4 {911674363964239/5847120243087331}
R4_0 n4 n5 {2213121256949281/2500000000000000000}
C4_1 n4 n5 {991415183111297/1264640718256732}
R5_0 n5 n6 {669747528765221/625000000000000000}
C5_1 n5 n6 {4402366779154595/2678990115060884}
R6_0 n6 n7 {10402434203478109/100000000000000000000}
C6_1 n6 n7 {446826397274877500/10402434203478109}
R7_0 n7 n8 {1704668836420273/10000000000000000000}
C7_1 n7 n8 {113378688849266570/1704668836420273}
R8_0 n8 n9 {3807091918791863/25000000000000000000}
C8_1 n8 n9 {140382606959355250/292853224522451}
R9_0 n9 n10 {1377246503905999/20000000000000000000}
C9_1 n9 n10 {3704582328130076600/1377246503905999}
R10_0 n10 n11 {863694833098399/2000000000000000000}
C10_1 n10 n11 {940008669271086600/863694833098399}
R11_0 n11 n12 {180186946669049/625000000000000000}
C11_1 n11 n12 {745374427566383875/180186946669049}
R12_0 n12 n13 {611210217590689/500000000000000000}
C12_1 n12 n13 {1513063253463264200/611210217590689}
R13_0 n13 portn {29965230964417133/100000000000000000000}
C13_1 n13 portn {69805075760120700000/2724111905856103}
.ends NONAGON_POSITIVE_REAL
