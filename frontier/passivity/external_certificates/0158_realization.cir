* Exact decimal-rational passive realization; s=+i*2*pi*f_hz
.subckt NONAGON_POSITIVE_REAL portp portn
R0_0 portp n1 {13659113131740013/1000000000000000000}
L1_0 n1 n2 {4584071552101437/50000000000000000000000}
C2_0 n2 n3 {100000000000000000/28326072572071}
R3_0 n3 n4 {9219020770808567/5000000000000000000}
C3_1 n3 n4 {2735023091892717/18438041541617134}
R4_0 n4 n5 {7170222849338463/10000000000000000000}
C4_1 n4 n5 {6939906281779079/7170222849338463}
R5_0 n5 n6 {7011719139021533/5000000000000000000}
C5_1 n5 n6 {8804733558309190/7011719139021533}
R6_0 n6 n7 {12158851419489043/50000000000000000000}
C6_1 n6 n7 {3649947780943236500/12158851419489043}
R7_0 n7 n8 {5438183938782317/1000000000000000000000}
C7_1 n7 n8 {185229116406503830000/5438183938782317}
R8_0 n8 n9 {427439275784921/1000000000000000000}
C8_1 n8 n9 {470004334635543300/427439275784921}
R9_0 n9 n10 {47849812761591843/100000000000000000000}
C9_1 n9 n10 {119259908410621420000/47849812761591843}
R10_0 n10 n11 {6324322694674929/10000000000000000000}
C10_1 n10 n11 {30261265069265284000/6324322694674929}
R11_0 n11 portn {1801799521985191/1250000000000000000}
C11_1 n11 portn {9598197917016596250/1801799521985191}
.ends NONAGON_POSITIVE_REAL
