* Exact decimal-rational passive realization; s=+i*2*pi*f_hz
.subckt NONAGON_POSITIVE_REAL portp portn
R0_0 portp n1 {1392891980285289/100000000000000000}
L1_0 n1 n2 {9377953120690653/100000000000000000000000}
C2_0 n2 n3 {50000000000000000000/18117763954616397}
R3_0 n3 n4 {7456427680236561/5000000000000000000}
C3_1 n3 n4 {911674363964239/4970951786824374}
R4_0 n4 n5 {199831392561717/156250000000000000}
C4_1 n4 n5 {141630740444471/261004267835712}
R5_0 n5 n6 {1843153517954559/2500000000000000000}
C5_1 n5 n6 {4402366779154595/1843153517954559}
R6_0 n6 n7 {9203640887544969/25000000000000000000}
C6_1 n6 n7 {111706599318719375/9203640887544969}
R7_0 n7 n8 {8250580939227613/100000000000000000000}
C7_1 n7 n8 {410985025682641200/1178654419889659}
R8_0 n8 n9 {14435342512101/156250000000000000}
C8_1 n8 n9 {26071055578165975/32995068599088}
R9_0 n9 n10 {2075611800470489/20000000000000000000}
C9_1 n9 n10 {3704582328130076600/2075611800470489}
R10_0 n10 n11 {255790887809963/625000000000000000}
C10_1 n10 n11 {587505418294429125/511581775619926}
R11_0 n11 n12 {13801649355830943/50000000000000000000}
C11_1 n11 n12 {59629954205310710000/13801649355830943}
R12_0 n12 portn {12547701678839833/10000000000000000000}
C12_1 n12 portn {30261265069265284000/12547701678839833}
.ends NONAGON_POSITIVE_REAL
