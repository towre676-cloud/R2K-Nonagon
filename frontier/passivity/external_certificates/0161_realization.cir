* Exact decimal-rational passive realization; s=+i*2*pi*f_hz
.subckt NONAGON_POSITIVE_REAL portp portn
R0_0 portp n1 {13893499595643413/1000000000000000000}
L1_0 n1 n2 {1179745683188449/12500000000000000000000}
C2_0 n2 n3 {100000000000000000000/31722508540631323}
R3_0 n3 n4 {40275012436729/25000000000000000}
C3_1 n3 n4 {2735023091892717/16110004974691600}
R4_0 n4 n5 {5524231731627409/5000000000000000000}
C4_1 n4 n5 {6939906281779079/11048463463254818}
R5_0 n5 n6 {1099908858857143/1250000000000000000}
C5_1 n5 n6 {4402366779154595/2199817717714286}
R6_0 n6 n7 {1522917255200737/5000000000000000000}
C6_1 n6 n7 {22341319863743875/1522917255200737}
R7_0 n7 n8 {10315293129781609/100000000000000000000}
C7_1 n7 n8 {2876895179778488400/10315293129781609}
R8_0 n8 n9 {3566085942807777/50000000000000000000}
C8_1 n8 n9 {3649947780943236500/3566085942807777}
R9_0 n9 n10 {1704048283898167/12500000000000000000}
C9_1 n9 n10 {2315363955081297875/1704048283898167}
R10_0 n10 n11 {34803026128281113/100000000000000000000}
C10_1 n10 n11 {47000433463554330000/34803026128281113}
R11_0 n11 n12 {20586446171200383/50000000000000000000}
C11_1 n11 n12 {312198713116810000/107782440686913}
R12_0 n12 n13 {2137454098009937/2500000000000000000}
C12_1 n12 n13 {7565316267316321000/2137454098009937}
R13_0 n13 portn {867911469250109/1000000000000000000}
C13_1 n13 portn {7678558333613277000/867911469250109}
.ends NONAGON_POSITIVE_REAL
