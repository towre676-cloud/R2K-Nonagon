* Exact decimal-rational passive realization; s=+i*2*pi*f_hz
.subckt NONAGON_POSITIVE_REAL portp portn
R0_0 portp n1 {13902252107810051/1000000000000000000}
L1_0 n1 n2 {9427583101681911/100000000000000000000000}
C2_0 n2 n3 {10000000000000000000/3330322694541353}
R3_0 n3 n4 {16205785937384867/10000000000000000000}
C3_1 n3 n4 {2735023091892717/16205785937384867}
R4_0 n4 n5 {9824414464970827/10000000000000000000}
C4_1 n4 n5 {6939906281779079/9824414464970827}
R5_0 n5 n6 {12788816562747253/10000000000000000000}
C5_1 n5 n6 {17609467116618380/12788816562747253}
R6_0 n6 n7 {6486132706954441/100000000000000000000}
C6_1 n6 n7 {2876895179778488400/6486132706954441}
R7_0 n7 n8 {3294373522033911/20000000000000000000}
C7_1 n7 n8 {1459979112377294600/3294373522033911}
R8_0 n8 n9 {1278172000897807/25000000000000000000}
C8_1 n8 n9 {4630727910162595750/1278172000897807}
R9_0 n9 n10 {850376194746253/2000000000000000000}
C9_1 n9 n10 {940008669271086600/850376194746253}
R10_0 n10 n11 {16157919543812737/50000000000000000000}
C10_1 n10 n11 {59629954205310710000/16157919543812737}
R11_0 n11 n12 {10310527242954003/10000000000000000000}
C11_1 n11 n12 {30261265069265284000/10310527242954003}
R12_0 n12 portn {5345907245549223/10000000000000000000}
C12_1 n12 portn {25595194445377590000/1781969081849741}
.ends NONAGON_POSITIVE_REAL
