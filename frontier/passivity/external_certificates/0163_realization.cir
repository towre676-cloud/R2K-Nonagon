* Exact decimal-rational passive realization; s=+i*2*pi*f_hz
.subckt NONAGON_POSITIVE_REAL portp portn
R0_0 portp n1 {3467038181396561/250000000000000000}
L1_0 n1 n2 {2366599965962489/25000000000000000000000}
C2_0 n2 n3 {5000000000000000000/1585320627496217}
R3_0 n3 n4 {17114978515618807/10000000000000000000}
C3_1 n3 n4 {2735023091892717/17114978515618807}
R4_0 n4 n5 {8868847704599183/10000000000000000000}
C4_1 n4 n5 {991415183111297/1266978243514169}
R5_0 n5 n6 {645462908490333/500000000000000000}
C5_1 n5 n6 {880473355830919/645462908490333}
R6_0 n6 n7 {5366925125465133/2500000000000000000000}
C6_1 n6 n7 {11170659931871937500/5366925125465133}
R7_0 n7 n8 {6593501588680061/50000000000000000000}
C7_1 n7 n8 {1438447589889244200/6593501588680061}
R8_0 n8 n9 {2052933612731971/25000000000000000000}
C8_1 n8 n9 {1824973890471618250/2052933612731971}
R9_0 n9 n10 {774473555427989/6250000000000000000}
C9_1 n9 n10 {2315363955081297875/1548947110855978}
R10_0 n10 n11 {18110981920842453/50000000000000000000}
C10_1 n10 n11 {7833405577259055000/6036993973614151}
R11_0 n11 n12 {3934912750410851/10000000000000000000}
C11_1 n11 n12 {11925990841062142000/3934912750410851}
R12_0 n12 n13 {8787208572971991/10000000000000000000}
C12_1 n12 n13 {30261265069265284000/8787208572971991}
R13_0 n13 portn {8476485807635679/10000000000000000000}
C13_1 n13 portn {25595194445377590000/2825495269211893}
.ends NONAGON_POSITIVE_REAL
