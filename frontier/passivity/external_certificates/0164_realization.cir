* Exact decimal-rational passive realization; s=+i*2*pi*f_hz
.subckt NONAGON_POSITIVE_REAL portp portn
R0_0 portp n1 {6916755528161441/500000000000000000}
L1_0 n1 n2 {9246701854764959/100000000000000000000000}
C2_0 n2 n3 {78125000000000000/27627255188161}
R3_0 n3 n4 {7783182678751823/5000000000000000000}
C3_1 n3 n4 {2735023091892717/15566365357503646}
R4_0 n4 n5 {2849930200565049/2500000000000000000}
C4_1 n4 n5 {991415183111297/1628531543180028}
R5_0 n5 n6 {8281303400221/10000000000000000}
C5_1 n5 n6 {880473355830919/414065170011050}
R6_0 n6 n7 {77156082167233/312500000000000000}
C6_1 n6 n7 {22341319863743875/1234497314675728}
R7_0 n7 n8 {6991065561677569/100000000000000000000}
C7_1 n7 n8 {1133786888492665700/6991065561677569}
R8_0 n8 n9 {1930546545114391/100000000000000000000}
C8_1 n8 n9 {2876895179778488400/1930546545114391}
R9_0 n9 n10 {7438127467961139/50000000000000000000}
C9_1 n9 n10 {3649947780943236500/7438127467961139}
R10_0 n10 n11 {2854421327066387/50000000000000000000}
C10_1 n10 n11 {9261455820325191500/2854421327066387}
R11_0 n11 n12 {1833118986374441/4000000000000000000}
C11_1 n11 n12 {1880017338542173200/1833118986374441}
R12_0 n12 n13 {11101964580597547/50000000000000000000}
C12_1 n12 n13 {59629954205310710000/11101964580597547}
R13_0 n13 portn {657761133717489/500000000000000000}
C13_1 n13 portn {1513063253463264200/657761133717489}
.ends NONAGON_POSITIVE_REAL
