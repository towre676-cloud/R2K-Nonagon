* Exact decimal-rational passive realization; s=+i*2*pi*f_hz
.subckt NONAGON_POSITIVE_REAL portp portn
R0_0 portp n1 {3378571158631877/250000000000000000}
L1_0 n1 n2 {36524114503133/390625000000000000000}
C2_0 n2 n3 {25000000000000000000/8163632430464259}
R3_0 n3 n4 {18058973811903853/10000000000000000000}
C3_1 n3 n4 {2735023091892717/18058973811903853}
R4_0 n4 n5 {8654718566676263/10000000000000000000}
C4_1 n4 n5 {6939906281779079/8654718566676263}
R5_0 n5 n6 {2592436826761621/2500000000000000000}
C5_1 n5 n6 {4402366779154595/2592436826761621}
R6_0 n6 n7 {91834155526329/625000000000000000}
C6_1 n6 n7 {22341319863743875/734673244210632}
R7_0 n7 n8 {1830047682355661/25000000000000000000}
C7_1 n7 n8 {283446722123166425/1830047682355661}
R8_0 n8 n9 {3301203370072323/50000000000000000000}
C8_1 n8 n9 {479482529963081400/1100401123357441}
R9_0 n9 n10 {8557413913819583/100000000000000000000}
C9_1 n9 n10 {7299895561886473000/8557413913819583}
R10_0 n10 n11 {6255162972078389/50000000000000000000}
C10_1 n10 n11 {9261455820325191500/6255162972078389}
R11_0 n11 n12 {9251202016849281/25000000000000000000}
C11_1 n11 n12 {3916702788629527500/3083734005616427}
R12_0 n12 n13 {1893950602446421/5000000000000000000}
C12_1 n12 n13 {5962995420531071000/1893950602446421}
R13_0 n13 n14 {9305202620081899/10000000000000000000}
C13_1 n13 n14 {30261265069265284000/9305202620081899}
R14_0 n14 portn {6774514731673967/10000000000000000000}
C14_1 n14 portn {76785583336132770000/6774514731673967}
.ends NONAGON_POSITIVE_REAL
