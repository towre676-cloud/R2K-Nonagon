* Exact decimal-rational passive realization; s=+i*2*pi*f_hz
.subckt NONAGON_POSITIVE_REAL portp portn
R0_0 portp n1 {13808333202949613/1000000000000000000}
L1_0 n1 n2 {36388677194791/390625000000000000000}
C2_0 n2 n3 {100000000000000000000/31683065403720643}
R3_0 n3 n4 {4068124777686983/2500000000000000000}
C3_1 n3 n4 {2735023091892717/16272499110747932}
R4_0 n4 n5 {2354030524119759/2500000000000000000}
C4_1 n4 n5 {6939906281779079/9416122096479036}
R5_0 n5 n6 {11852112251977383/10000000000000000000}
C5_1 n5 n6 {17609467116618380/11852112251977383}
R6_0 n6 n7 {1824019051402081/25000000000000000000}
C6_1 n6 n7 {719223794944622100/1824019051402081}
R7_0 n7 n8 {332933765231559/2500000000000000000}
C7_1 n7 n8 {182497389047161825/332933765231559}
R8_0 n8 n9 {6732907985328477/100000000000000000000}
C8_1 n8 n9 {18522911640650383000/6732907985328477}
R9_0 n9 n10 {504873601159893/1250000000000000000}
C9_1 n9 n10 {195835139431476375/168291200386631}
R10_0 n10 n11 {1871314627957887/5000000000000000000}
C10_1 n10 n11 {5962995420531071000/1871314627957887}
R11_0 n11 n12 {4696659791709531/5000000000000000000}
C11_1 n11 n12 {15130632534632642000/4696659791709531}
R12_0 n12 portn {3683895360079577/5000000000000000000}
C12_1 n12 portn {38392791668066385000/3683895360079577}
.ends NONAGON_POSITIVE_REAL
