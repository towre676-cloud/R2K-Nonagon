* Exact decimal-rational passive realization; s=+i*2*pi*f_hz
.subckt NONAGON_POSITIVE_REAL portp portn
R0_0 portp n1 {2754575627672879/200000000000000000}
L1_0 n1 n2 {73084294204387/781250000000000000000}
C2_0 n2 n3 {2000000000000000000/605515447834443}
R3_0 n3 n4 {17345497238172441/10000000000000000000}
C3_1 n3 n4 {911674363964239/5781832412724147}
R4_0 n4 n5 {7973699716284931/10000000000000000000}
C4_1 n4 n5 {6939906281779079/7973699716284931}
R5_0 n5 n6 {6188566595543983/5000000000000000000}
C5_1 n5 n6 {8804733558309190/6188566595543983}
R6_0 n6 n7 {2659346773260497/25000000000000000000}
C6_1 n6 n7 {719223794944622100/2659346773260497}
R7_0 n7 n8 {5201581848913201/50000000000000000000}
C7_1 n7 n8 {3649947780943236500/5201581848913201}
R8_0 n8 n9 {9110789693025589/100000000000000000000}
C8_1 n8 n9 {18522911640650383000/9110789693025589}
R9_0 n9 n10 {19583786200001553/50000000000000000000}
C9_1 n9 n10 {2611135192419685000/2175976244444617}
R10_0 n10 n11 {247525068971273/625000000000000000}
C10_1 n10 n11 {745374427566383875/247525068971273}
R11_0 n11 n12 {837830988530667/1000000000000000000}
C11_1 n11 n12 {3026126506926528400/837830988530667}
R12_0 n12 portn {2471867495055661/2500000000000000000}
C12_1 n12 portn {19196395834033192500/2471867495055661}
.ends NONAGON_POSITIVE_REAL
