* Exact decimal-rational passive realization; s=+i*2*pi*f_hz
.subckt NONAGON_POSITIVE_REAL portp portn
R0_0 portp n1 {6830119163732511/500000000000000000}
L1_0 n1 n2 {9395913621823071/100000000000000000000000}
C2_0 n2 n3 {8000000000000000/2566110967601}
R3_0 n3 n4 {17614289670916901/10000000000000000000}
C3_1 n3 n4 {2735023091892717/17614289670916901}
R4_0 n4 n5 {1888889982101989/2500000000000000000}
C4_1 n4 n5 {6939906281779079/7555559928407956}
R5_0 n5 n6 {6311690480987599/5000000000000000000}
C5_1 n5 n6 {8804733558309190/6311690480987599}
R6_0 n6 n7 {21229053528780823/100000000000000000000}
C6_1 n6 n7 {7299895561886473000/21229053528780823}
R7_0 n7 n8 {5427682565430573/500000000000000000000}
C7_1 n7 n8 {92614558203251915000/5427682565430573}
R8_0 n8 n9 {2406898129842279/5000000000000000000}
C8_1 n8 n9 {261113519241968500/267433125538031}
R9_0 n9 n10 {5189764500949241/20000000000000000000}
C9_1 n9 n10 {23851981682124284000/5189764500949241}
R10_0 n10 n11 {11183221704487369/10000000000000000000}
C10_1 n10 n11 {30261265069265284000/11183221704487369}
R11_0 n11 portn {317720521631811/625000000000000000}
C11_1 n11 portn {1599699652836099375/105906840543937}
.ends NONAGON_POSITIVE_REAL
