* Exact decimal-rational passive realization; s=+i*2*pi*f_hz
.subckt NONAGON_POSITIVE_REAL portp portn
R0_0 portp n1 {13817150106362953/1000000000000000000}
L1_0 n1 n2 {9320681024026313/100000000000000000000000}
C2_0 n2 n3 {50000000000000000000/17227171831928843}
R3_0 n3 n4 {1558145731459987/1000000000000000000}
C3_1 n3 n4 {2735023091892717/15581457314599870}
R4_0 n4 n5 {2248597581464261/2000000000000000000}
C4_1 n4 n5 {6939906281779079/11242987907321305}
R5_0 n5 n6 {1621906316733511/2000000000000000000}
C5_1 n5 n6 {3521893423323676/1621906316733511}
R6_0 n6 n7 {11099314105188267/50000000000000000000}
C6_1 n6 n7 {223413198637438750/11099314105188267}
R7_0 n7 n8 {8995442801708111/100000000000000000000}
C7_1 n7 n8 {1133786888492665700/8995442801708111}
R8_0 n8 n9 {7012985749795787/500000000000000000000}
C8_1 n8 n9 {14384475898892442000/7012985749795787}
R9_0 n9 n10 {1481201760115003/10000000000000000000}
C9_1 n9 n10 {729989556188647300/1481201760115003}
R10_0 n10 n11 {3683421501442849/50000000000000000000}
C10_1 n10 n11 {9261455820325191500/3683421501442849}
R11_0 n11 n12 {4195406668987227/10000000000000000000}
C11_1 n11 n12 {1566681115451811000/1398468889662409}
R12_0 n12 n13 {5879357207821573/20000000000000000000}
C12_1 n12 n13 {23851981682124284000/5879357207821573}
R13_0 n13 n14 {11832695570125557/10000000000000000000}
C13_1 n13 n14 {30261265069265284000/11832695570125557}
R14_0 n14 portn {5348190980040339/25000000000000000000}
C14_1 n14 portn {63987986113443975000/1782730326680113}
.ends NONAGON_POSITIVE_REAL
