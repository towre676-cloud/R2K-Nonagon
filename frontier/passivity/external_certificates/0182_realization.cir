* Exact decimal-rational passive realization; s=+i*2*pi*f_hz
.subckt NONAGON_POSITIVE_REAL portp portn
R0_0 portp n1 {1724406898488001/125000000000000000}
L1_0 n1 n2 {936371942294297/10000000000000000000000}
C2_0 n2 n3 {100000000000000000000/33109179639693537}
R3_0 n3 n4 {8295096567950117/5000000000000000000}
C3_1 n3 n4 {2735023091892717/16590193135900234}
R4_0 n4 n5 {2214296112029667/2500000000000000000}
C4_1 n4 n5 {6939906281779079/8857184448118668}
R5_0 n5 n6 {6210729621117737/5000000000000000000}
C5_1 n5 n6 {8804733558309190/6210729621117737}
R6_0 n6 n7 {799454185929839/50000000000000000000}
C6_1 n6 n7 {1438447589889244200/799454185929839}
R7_0 n7 n8 {11423214173081957/50000000000000000000}
C7_1 n7 n8 {3649947780943236500/11423214173081957}
R8_0 n8 n9 {2371305256044331/5000000000000000000}
C8_1 n8 n9 {2350021673177716500/2371305256044331}
R9_0 n9 n10 {27253285162878477/100000000000000000000}
C9_1 n9 n10 {119259908410621420000/27253285162878477}
R10_0 n10 n11 {11135560435420937/10000000000000000000}
C10_1 n10 n11 {30261265069265284000/11135560435420937}
R11_0 n11 portn {4393226706501397/10000000000000000000}
C11_1 n11 portn {76785583336132770000/4393226706501397}
.ends NONAGON_POSITIVE_REAL
