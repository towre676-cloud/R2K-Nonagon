* Exact decimal-rational passive realization; s=+i*2*pi*f_hz
.subckt NONAGON_POSITIVE_REAL portp portn
R0_0 portp n1 {3439900674719777/250000000000000000}
L1_0 n1 n2 {940409507324939/10000000000000000000000}
C2_0 n2 n3 {10000000000000000000/3129202061979649}
R3_0 n3 n4 {4399431848979343/2500000000000000000}
C3_1 n3 n4 {2735023091892717/17597727395917372}
R4_0 n4 n5 {7822087094173439/10000000000000000000}
C4_1 n4 n5 {6939906281779079/7822087094173439}
R5_0 n5 n6 {1568136080155729/1250000000000000000}
C5_1 n5 n6 {4402366779154595/3136272160311458}
R6_0 n6 n7 {9484872758303783/100000000000000000000}
C6_1 n6 n7 {2876895179778488400/9484872758303783}
R7_0 n7 n8 {1268386580672867/10000000000000000000}
C7_1 n7 n8 {729989556188647300/1268386580672867}
R8_0 n8 n9 {1068190712756059/12500000000000000000}
C8_1 n8 n9 {2315363955081297875/1068190712756059}
R9_0 n9 n10 {2008708297159317/5000000000000000000}
C9_1 n9 n10 {783340557725905500/669569432386439}
R10_0 n10 n11 {36352344315393297/100000000000000000000}
C10_1 n10 n11 {119259908410621420000/36352344315393297}
R11_0 n11 n12 {287033956516651/312500000000000000}
C11_1 n11 n12 {945664533414540125/287033956516651}
R12_0 n12 portn {1632310264914181/2000000000000000000}
C12_1 n12 portn {15357116667226554000/1632310264914181}
.ends NONAGON_POSITIVE_REAL
