* Exact decimal-rational passive realization; s=+i*2*pi*f_hz
.subckt NONAGON_POSITIVE_REAL portp portn
R0_0 portp n1 {13825931257440173/1000000000000000000}
L1_0 n1 n2 {469415011439121/5000000000000000000000}
C2_0 n2 n3 {25000000000000000000/8513760700168021}
R3_0 n3 n4 {7573809842587/5000000000000000}
C3_1 n3 n4 {2735023091892717/15147619685174000}
R4_0 n4 n5 {2321526995715333/2000000000000000000}
C4_1 n4 n5 {991415183111297/1658233568368095}
R5_0 n5 n6 {1895815452344299/2500000000000000000}
C5_1 n5 n6 {4402366779154595/1895815452344299}
R6_0 n6 n7 {2342424805630429/10000000000000000000}
C6_1 n6 n7 {44682639727487750/2342424805630429}
R7_0 n7 n8 {1791816983755939/20000000000000000000}
C7_1 n7 n8 {226757377698533140/1791816983755939}
R8_0 n8 n9 {171915961616561/6250000000000000000}
C8_1 n8 n9 {179805948736155525/171915961616561}
R9_0 n9 n10 {12220290314776257/100000000000000000000}
C9_1 n9 n10 {1042842223126639000/1745755759253751}
R10_0 n10 n11 {4782490155241063/50000000000000000000}
C10_1 n10 n11 {9261455820325191500/4782490155241063}
R11_0 n11 n12 {2109455945252217/5000000000000000000}
C11_1 n11 n12 {261113519241968500/234383993916913}
R12_0 n12 n13 {13249923318501083/50000000000000000000}
C12_1 n12 n13 {59629954205310710000/13249923318501083}
R13_0 n13 n14 {12220106162219853/10000000000000000000}
C13_1 n13 n14 {30261265069265284000/12220106162219853}
R14_0 n14 portn {2069563131841657/10000000000000000000}
C14_1 n14 portn {76785583336132770000/2069563131841657}
.ends NONAGON_POSITIVE_REAL
