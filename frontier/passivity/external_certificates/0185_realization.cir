* Exact decimal-rational passive realization; s=+i*2*pi*f_hz
.subckt NONAGON_POSITIVE_REAL portp portn
R0_0 portp n1 {6896051009352537/500000000000000000}
L1_0 n1 n2 {4724902410382929/50000000000000000000000}
C2_0 n2 n3 {50000000000000000000/14237973686284387}
R3_0 n3 n4 {16186841066591477/10000000000000000000}
C3_1 n3 n4 {2735023091892717/16186841066591477}
R4_0 n4 n5 {2580977383059789/2500000000000000000}
C4_1 n4 n5 {991415183111297/1474844218891308}
R5_0 n5 n6 {2057723895561169/2500000000000000000}
C5_1 n5 n6 {4402366779154595/2057723895561169}
R6_0 n6 n7 {2629039459312489/10000000000000000000}
C6_1 n6 n7 {44682639727487750/2629039459312489}
R7_0 n7 n8 {1519978217237339/200000000000000000000}
C7_1 n7 n8 {2267573776985331400/1519978217237339}
R8_0 n8 n9 {2719875677082621/25000000000000000000}
C8_1 n8 n9 {239741264981540700/906625225694207}
R9_0 n9 n10 {6409396141824959/100000000000000000000}
C9_1 n9 n10 {7299895561886473000/6409396141824959}
R10_0 n10 n11 {900520508010809/6250000000000000000}
C10_1 n10 n11 {2315363955081297875/1801041016021618}
R11_0 n11 n12 {278340488963943/800000000000000000}
C11_1 n11 n12 {125334489236144880/92780162987981}
R12_0 n12 n13 {352309227735603/781250000000000000}
C12_1 n12 n13 {3726872137831919375/1409236910942412}
R13_0 n13 n14 {6902770807426241/10000000000000000000}
C13_1 n13 n14 {30261265069265284000/6902770807426241}
R14_0 n14 portn {328352125885663/250000000000000000}
C14_1 n14 portn {174512689400301750/29850193262333}
.ends NONAGON_POSITIVE_REAL
