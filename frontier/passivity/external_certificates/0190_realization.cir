* Exact decimal-rational passive realization; s=+i*2*pi*f_hz
.subckt NONAGON_POSITIVE_REAL portp portn
R0_0 portp n1 {1379418219906689/100000000000000000}
L1_0 n1 n2 {2374758364066909/25000000000000000000000}
C2_0 n2 n3 {25000000000000000000/7669393772003589}
R3_0 n3 n4 {1554514850293789/1000000000000000000}
C3_1 n3 n4 {2735023091892717/15545148502937890}
R4_0 n4 n5 {9890389778859621/10000000000000000000}
C4_1 n4 n5 {6939906281779079/9890389778859621}
R5_0 n5 n6 {2267620926287859/2000000000000000000}
C5_1 n5 n6 {3521893423323676/2267620926287859}
R6_0 n6 n7 {11447180083339669/200000000000000000000}
C6_1 n6 n7 {5753790359556976800/11447180083339669}
R7_0 n7 n8 {446695497620247/2500000000000000000}
C7_1 n7 n8 {182497389047161825/446695497620247}
R8_0 n8 n9 {3877315336381717/100000000000000000000}
C8_1 n8 n9 {18522911640650383000/3877315336381717}
R9_0 n9 n10 {278924651459169/625000000000000000}
C9_1 n9 n10 {195835139431476375/185949767639446}
R10_0 n10 n11 {3194053920302339/10000000000000000000}
C10_1 n10 n11 {11925990841062142000/3194053920302339}
R11_0 n11 n12 {1985868823740473/2000000000000000000}
C11_1 n11 n12 {6052253013853056800/1985868823740473}
R12_0 n12 portn {3960546115208411/5000000000000000000}
C12_1 n12 portn {38392791668066385000/3960546115208411}
.ends NONAGON_POSITIVE_REAL
