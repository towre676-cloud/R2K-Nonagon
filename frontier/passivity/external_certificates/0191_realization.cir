* Exact decimal-rational passive realization; s=+i*2*pi*f_hz
.subckt NONAGON_POSITIVE_REAL portp portn
R0_0 portp n1 {6880304533196657/500000000000000000}
L1_0 n1 n2 {2385066876591899/25000000000000000000000}
C2_0 n2 n3 {2000000000000000000/585900579137381}
R3_0 n3 n4 {16492659113607419/10000000000000000000}
C3_1 n3 n4 {2735023091892717/16492659113607419}
R4_0 n4 n5 {8900509768583943/10000000000000000000}
C4_1 n4 n5 {6939906281779079/8900509768583943}
R5_0 n5 n6 {11499829066429633/10000000000000000000}
C5_1 n5 n6 {17609467116618380/11499829066429633}
R6_0 n6 n7 {11818388302049593/100000000000000000000}
C6_1 n6 n7 {2876895179778488400/11818388302049593}
R7_0 n7 n8 {1314482024179251/12500000000000000000}
C7_1 n7 n8 {912486945235809125/1314482024179251}
R8_0 n8 n9 {4016704006099/39062500000000000}
C8_1 n8 n9 {463072791016259575/257069056390336}
R9_0 n9 n10 {975086014215391/2500000000000000000}
C9_1 n9 n10 {1175010836588858250/975086014215391}
R10_0 n10 n11 {3920088797802261/10000000000000000000}
C10_1 n10 n11 {11925990841062142000/3920088797802261}
R11_0 n11 n12 {521449093964799/625000000000000000}
C11_1 n11 n12 {1891329066829080250/521449093964799}
R12_0 n12 portn {1089746798268083/1000000000000000000}
C12_1 n12 portn {7678558333613277000/1089746798268083}
.ends NONAGON_POSITIVE_REAL
