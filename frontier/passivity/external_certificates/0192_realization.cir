* Exact decimal-rational passive realization; s=+i*2*pi*f_hz
.subckt NONAGON_POSITIVE_REAL portp portn
R0_0 portp n1 {277982692058401/20000000000000000}
L1_0 n1 n2 {9489450761855759/100000000000000000000000}
C2_0 n2 n3 {25000000000000000000/8032091706758221}
R3_0 n3 n4 {113753233480791/78125000000000000}
C3_1 n3 n4 {911674363964239/4853471295180416}
R4_0 n4 n5 {6176131420505169/5000000000000000000}
C4_1 n4 n5 {6939906281779079/12352262841010338}
R5_0 n5 n6 {820689124592057/1250000000000000000}
C5_1 n5 n6 {4402366779154595/1641378249184114}
R6_0 n6 n7 {403032922798873/1250000000000000000}
C6_1 n6 n7 {22341319863743875/1612131691195492}
R7_0 n7 n8 {8210093439027199/100000000000000000000}
C7_1 n7 n8 {2876895179778488400/8210093439027199}
R8_0 n8 n9 {9220662956442593/100000000000000000000}
C8_1 n8 n9 {7299895561886473000/9220662956442593}
R9_0 n9 n10 {13269615128344873/100000000000000000000}
C9_1 n9 n10 {18522911640650383000/13269615128344873}
R10_0 n10 n11 {3685443953881529/10000000000000000000}
C10_1 n10 n11 {4700043346355433000/3685443953881529}
R11_0 n11 n12 {35929119524509567/100000000000000000000}
C11_1 n11 n12 {119259908410621420000/35929119524509567}
R12_0 n12 n13 {1051579935091121/1000000000000000000}
C12_1 n12 n13 {3026126506926528400/1051579935091121}
R13_0 n13 portn {5623011856641199/10000000000000000000}
C13_1 n13 portn {76785583336132770000/5623011856641199}
.ends NONAGON_POSITIVE_REAL
