* Exact decimal-rational passive realization; s=+i*2*pi*f_hz
.subckt NONAGON_POSITIVE_REAL portp portn
R0_0 portp n1 {13874261219751263/1000000000000000000}
L1_0 n1 n2 {953482952145383/10000000000000000000000}
C2_0 n2 n3 {1250000000000000000/370323582295083}
R3_0 n3 n4 {15585992830959537/10000000000000000000}
C3_1 n3 n4 {911674363964239/5195330943653179}
R4_0 n4 n5 {2510275743364687/2500000000000000000}
C4_1 n4 n5 {6939906281779079/10041102973458748}
R5_0 n5 n6 {8677904971169/7812500000000000}
C5_1 n5 n6 {880473355830919/555385918154816}
R6_0 n6 n7 {300484085248921/4000000000000000000}
C6_1 n6 n7 {16439401027305648/42926297892703}
R7_0 n7 n8 {3725707901078013/25000000000000000000}
C7_1 n7 n8 {1824973890471618250/3725707901078013}
R8_0 n8 n9 {7948393225274139/100000000000000000000}
C8_1 n8 n9 {18522911640650383000/7948393225274139}
R9_0 n9 n10 {2520071247212409/6250000000000000000}
C9_1 n9 n10 {979175697157381875/840023749070803}
R10_0 n10 n11 {954891386704217/2500000000000000000}
C10_1 n10 n11 {2981497710265535500/954891386704217}
R11_0 n11 n12 {8697374978907549/10000000000000000000}
C11_1 n11 n12 {30261265069265284000/8697374978907549}
R12_0 n12 portn {25375542531613/25000000000000000}
C12_1 n12 portn {191963958340331925/25375542531613}
.ends NONAGON_POSITIVE_REAL
