* Exact decimal-rational passive realization; s=+i*2*pi*f_hz
.subckt NONAGON_POSITIVE_REAL portp portn
R0_0 portp n1 {6920918192621657/500000000000000000}
L1_0 n1 n2 {1917376081032601/20000000000000000000000}
C2_0 n2 n3 {100000000000000000000/27935191254233163}
R3_0 n3 n4 {330511291490497/200000000000000000}
C3_1 n3 n4 {2735023091892717/16525564574524850}
R4_0 n4 n5 {2254779666709307/2500000000000000000}
C4_1 n4 n5 {6939906281779079/9019118666837228}
R5_0 n5 n6 {1389913982460223/1250000000000000000}
C5_1 n5 n6 {4402366779154595/2779827964920446}
R6_0 n6 n7 {1563091782959543/50000000000000000000}
C6_1 n6 n7 {223413198637438750/1563091782959543}
R7_0 n7 n8 {109735612987237/1000000000000000000}
C7_1 n7 n8 {28768951797784884/109735612987237}
R8_0 n8 n9 {5001522201849023/50000000000000000000}
C8_1 n8 n9 {3649947780943236500/5001522201849023}
R9_0 n9 n10 {1468523734703883/12500000000000000000}
C9_1 n9 n10 {2315363955081297875/1468523734703883}
R10_0 n10 n11 {3681461972059901/10000000000000000000}
C10_1 n10 n11 {4700043346355433000/3681461972059901}
R11_0 n11 n12 {5507178009255353/12500000000000000000}
C11_1 n11 n12 {14907488551327677500/5507178009255353}
R12_0 n12 n13 {1787392085547033/2500000000000000000}
C12_1 n12 n13 {7565316267316321000/1787392085547033}
R13_0 n13 portn {6710325119636683/5000000000000000000}
C13_1 n13 portn {38392791668066385000/6710325119636683}
.ends NONAGON_POSITIVE_REAL
