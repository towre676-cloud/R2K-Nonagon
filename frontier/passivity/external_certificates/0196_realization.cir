* Exact decimal-rational passive realization; s=+i*2*pi*f_hz
.subckt NONAGON_POSITIVE_REAL portp portn
R0_0 portp n1 {13925644987986449/1000000000000000000}
L1_0 n1 n2 {9379313013280077/100000000000000000000000}
C2_0 n2 n3 {10000000000000000000/3110649958333217}
R3_0 n3 n4 {14738453827128919/10000000000000000000}
C3_1 n3 n4 {2735023091892717/14738453827128919}
R4_0 n4 n5 {2369982471309707/2000000000000000000}
C4_1 n4 n5 {6939906281779079/11849912356548535}
R5_0 n5 n6 {1351623898513949/2000000000000000000}
C5_1 n5 n6 {3521893423323676/1351623898513949}
R6_0 n6 n7 {29290643730287913/100000000000000000000}
C6_1 n6 n7 {446826397274877500/29290643730287913}
R7_0 n7 n8 {4004904420279/312500000000000000}
C7_1 n7 n8 {56689344424633285/64078470724464}
R8_0 n8 n9 {8851715292487783/100000000000000000000}
C8_1 n8 n9 {2876895179778488400/8851715292487783}
R9_0 n9 n10 {3949497025944987/50000000000000000000}
C9_1 n9 n10 {3649947780943236500/3949497025944987}
R10_0 n10 n11 {15080881710215327/100000000000000000000}
C10_1 n10 n11 {18522911640650383000/15080881710215327}
R11_0 n11 n12 {681510050926793/2000000000000000000}
C11_1 n11 n12 {940008669271086600/681510050926793}
R12_0 n12 n13 {825834998387507/2000000000000000000}
C12_1 n12 n13 {2385198168212428400/825834998387507}
R13_0 n13 n14 {9198285923910269/10000000000000000000}
C13_1 n13 n14 {30261265069265284000/9198285923910269}
R14_0 n14 portn {8018807251002399/10000000000000000000}
C14_1 n14 portn {8531731481792530000/890978583444711}
.ends NONAGON_POSITIVE_REAL
