* Exact decimal-rational passive realization; s=+i*2*pi*f_hz
.subckt NONAGON_POSITIVE_REAL portp portn
R0_0 portp n1 {13898912097597227/1000000000000000000}
L1_0 n1 n2 {9428445030510777/100000000000000000000000}
C2_0 n2 n3 {10000000000000000000/3160070665334111}
R3_0 n3 n4 {3962688905805251/2500000000000000000}
C3_1 n3 n4 {2735023091892717/15850755623221004}
R4_0 n4 n5 {9482116605366379/10000000000000000000}
C4_1 n4 n5 {6939906281779079/9482116605366379}
R5_0 n5 n6 {11241226426856683/10000000000000000000}
C5_1 n5 n6 {17609467116618380/11241226426856683}
R6_0 n6 n7 {1126878727216709/20000000000000000000}
C6_1 n6 n7 {575379035955697680/1126878727216709}
R7_0 n7 n8 {8324961869173913/50000000000000000000}
C7_1 n7 n8 {3649947780943236500/8324961869173913}
R8_0 n8 n9 {237680919001949/4000000000000000000}
C8_1 n8 n9 {740916465626015320/237680919001949}
R9_0 n9 n10 {8576106555290427/20000000000000000000}
C9_1 n9 n10 {1044454076967874000/952900728365603}
R10_0 n10 n11 {6738069811462403/20000000000000000000}
C10_1 n10 n11 {23851981682124284000/6738069811462403}
R11_0 n11 n12 {10002828116415193/10000000000000000000}
C11_1 n11 n12 {30261265069265284000/10002828116415193}
R12_0 n12 portn {3447170012722963/5000000000000000000}
C12_1 n12 portn {38392791668066385000/3447170012722963}
.ends NONAGON_POSITIVE_REAL
