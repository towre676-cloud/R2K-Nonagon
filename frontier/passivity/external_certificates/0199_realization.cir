* Exact decimal-rational passive realization; s=+i*2*pi*f_hz
.subckt NONAGON_POSITIVE_REAL portp portn
R0_0 portp n1 {2772405479512111/200000000000000000}
L1_0 n1 n2 {4733708300819059/50000000000000000000000}
C2_0 n2 n3 {10000000000000000000/2976153602909759}
R3_0 n3 n4 {8428508279426011/5000000000000000000}
C3_1 n3 n4 {2735023091892717/16857016558852022}
R4_0 n4 n5 {8283349933539643/10000000000000000000}
C4_1 n4 n5 {6939906281779079/8283349933539643}
R5_0 n5 n6 {725012105755991/625000000000000000}
C5_1 n5 n6 {4402366779154595/2900048423023964}
R6_0 n6 n7 {2696208450207513/25000000000000000000}
C6_1 n6 n7 {239741264981540700/898736150069171}
R7_0 n7 n8 {2071282919210687/20000000000000000000}
C7_1 n7 n8 {16043726509640600/22761350760557}
R8_0 n8 n9 {11977562795718893/100000000000000000000}
C8_1 n8 n9 {18522911640650383000/11977562795718893}
R9_0 n9 n10 {937071584858171/2500000000000000000}
C9_1 n9 n10 {1175010836588858250/937071584858171}
R10_0 n10 n11 {6558956039803/16000000000000000}
C10_1 n10 n11 {95407926728497136/32794780199015}
R11_0 n11 n12 {2051264625407373/2500000000000000000}
C11_1 n11 n12 {7565316267316321000/2051264625407373}
R12_0 n12 portn {2640523341540077/2500000000000000000}
C12_1 n12 portn {19196395834033192500/2640523341540077}
.ends NONAGON_POSITIVE_REAL
