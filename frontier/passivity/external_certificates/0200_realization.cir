* Exact decimal-rational passive realization; s=+i*2*pi*f_hz
.subckt NONAGON_POSITIVE_REAL portp portn
R0_0 portp n1 {13731729571711593/1000000000000000000}
L1_0 n1 n2 {9392689706426893/100000000000000000000000}
C2_0 n2 n3 {62500000000000000/18609428003981}
R3_0 n3 n4 {7736660762335301/5000000000000000000}
C3_1 n3 n4 {2735023091892717/15473321524670602}
R4_0 n4 n5 {5257097684555109/5000000000000000000}
C4_1 n4 n5 {6939906281779079/10514195369110218}
R5_0 n5 n6 {3750033773045753/5000000000000000000}
C5_1 n5 n6 {8804733558309190/3750033773045753}
R6_0 n6 n7 {5116160137588709/25000000000000000000}
C6_1 n6 n7 {111706599318719375/5116160137588709}
R7_0 n7 n8 {60999143558949853/1000000000000000000000}
C7_1 n7 n8 {11337868884926657000/60999143558949853}
R8_0 n8 n9 {3305514301284761/50000000000000000000}
C8_1 n8 n9 {1438447589889244200/3305514301284761}
R9_0 n9 n10 {987826929287039/12500000000000000000}
C9_1 n9 n10 {912486945235809125/987826929287039}
R10_0 n10 n11 {15324164721551749/100000000000000000000}
C10_1 n10 n11 {18522911640650383000/15324164721551749}
R11_0 n11 n12 {139218484397179/400000000000000000}
C11_1 n11 n12 {188001733854217320/139218484397179}
R12_0 n12 n13 {815493136358907/2000000000000000000}
C12_1 n12 n13 {2385198168212428400/815493136358907}
R13_0 n13 n14 {9018112006305809/10000000000000000000}
C13_1 n13 n14 {30261265069265284000/9018112006305809}
R14_0 n14 portn {9157022307919617/10000000000000000000}
C14_1 n14 portn {25595194445377590000/3052340769306539}
.ends NONAGON_POSITIVE_REAL
