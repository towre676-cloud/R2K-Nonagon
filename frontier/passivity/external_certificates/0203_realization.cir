* Exact decimal-rational passive realization; s=+i*2*pi*f_hz
.subckt NONAGON_POSITIVE_REAL portp portn
R0_0 portp n1 {2734233867351743/200000000000000000}
L1_0 n1 n2 {592280485906477/6250000000000000000000}
C2_0 n2 n3 {1250000000000000000/340698880245213}
R3_0 n3 n4 {1093332125531877/625000000000000000}
C3_1 n3 n4 {911674363964239/5831104669503344}
R4_0 n4 n5 {7184452798866147/10000000000000000000}
C4_1 n4 n5 {991415183111297/1026350399838021}
R5_0 n5 n6 {5832812923755753/5000000000000000000}
C5_1 n5 n6 {8804733558309190/5832812923755753}
R6_0 n6 n7 {1194011918293159/12500000000000000000}
C6_1 n6 n7 {51373128210330150/170573131184737}
R7_0 n7 n8 {556079565471233/5000000000000000000}
C7_1 n7 n8 {364994778094323650/556079565471233}
R8_0 n8 n9 {722477749439737/6250000000000000000}
C8_1 n8 n9 {2315363955081297875/1444955498879474}
R9_0 n9 n10 {36993111142978813/100000000000000000000}
C9_1 n9 n10 {47000433463554330000/36993111142978813}
R10_0 n10 n11 {8719413283117931/20000000000000000000}
C10_1 n10 n11 {23851981682124284000/8719413283117931}
R11_0 n11 n12 {7143161620429691/10000000000000000000}
C11_1 n11 n12 {30261265069265284000/7143161620429691}
R12_0 n12 portn {13772729216795423/10000000000000000000}
C12_1 n12 portn {76785583336132770000/13772729216795423}
.ends NONAGON_POSITIVE_REAL
