* Exact decimal-rational passive realization; s=+i*2*pi*f_hz
.subckt NONAGON_POSITIVE_REAL portp portn
R0_0 portp n1 {6958923510893937/500000000000000000}
L1_0 n1 n2 {1880253771554661/20000000000000000000000}
C2_0 n2 n3 {100000000000000000000/29265513661978467}
R3_0 n3 n4 {2754631306082017/2000000000000000000}
C3_1 n3 n4 {2735023091892717/13773156530410085}
R4_0 n4 n5 {78388342233149/62500000000000000}
C4_1 n4 n5 {6939906281779079/12542134757303840}
R5_0 n5 n6 {2875962885196559/5000000000000000000}
C5_1 n5 n6 {8804733558309190/2875962885196559}
R6_0 n6 n7 {30344673094425247/100000000000000000000}
C6_1 n6 n7 {446826397274877500/30344673094425247}
R7_0 n7 n8 {16624859830946767/10000000000000000000000}
C7_1 n7 n8 {113378688849266570000/16624859830946767}
R8_0 n8 n9 {3656818199685529/50000000000000000000}
C8_1 n8 n9 {1438447589889244200/3656818199685529}
R9_0 n9 n10 {11426662031616183/100000000000000000000}
C9_1 n9 n10 {7299895561886473000/11426662031616183}
R10_0 n10 n11 {10674681187556863/100000000000000000000}
C10_1 n10 n11 {18522911640650383000/10674681187556863}
R11_0 n11 n12 {590253515477301/1562500000000000000}
C11_1 n11 n12 {979175697157381875/787004687303068}
R12_0 n12 n13 {9868419240113641/25000000000000000000}
C12_1 n12 n13 {29814977102655355000/9868419240113641}
R13_0 n13 n14 {8867468129427033/10000000000000000000}
C13_1 n13 n14 {30261265069265284000/8867468129427033}
R14_0 n14 portn {2447887095203341/2500000000000000000}
C14_1 n14 portn {1745126894003017500/222535190473031}
.ends NONAGON_POSITIVE_REAL
