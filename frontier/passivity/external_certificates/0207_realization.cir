* Exact decimal-rational passive realization; s=+i*2*pi*f_hz
.subckt NONAGON_POSITIVE_REAL portp portn
R0_0 portp n1 {1385057928027731/100000000000000000}
L1_0 n1 n2 {2372459362332883/25000000000000000000000}
C2_0 n2 n3 {10000000000000000000/2816397623443649}
R3_0 n3 n4 {402349913792853/250000000000000000}
C3_1 n3 n4 {911674363964239/5364665517238040}
R4_0 n4 n5 {8719757793807773/10000000000000000000}
C4_1 n4 n5 {6939906281779079/8719757793807773}
R5_0 n5 n6 {1315800252928607/1250000000000000000}
C5_1 n5 n6 {4402366779154595/2631600505857214}
R6_0 n6 n7 {23130205415438623/1000000000000000000000}
C6_1 n6 n7 {4468263972748775000/23130205415438623}
R7_0 n7 n8 {4185636971237101/50000000000000000000}
C7_1 n7 n8 {1438447589889244200/4185636971237101}
R8_0 n8 n9 {6973935902412703/50000000000000000000}
C8_1 n8 n9 {521421111563319500/996276557487529}
R9_0 n9 n10 {8018937281289151/100000000000000000000}
C9_1 n9 n10 {18522911640650383000/8018937281289151}
R10_0 n10 n11 {10059791360718681/25000000000000000000}
C10_1 n10 n11 {1305567596209842500/1117754595635409}
R11_0 n11 n12 {19732474640252003/50000000000000000000}
C11_1 n11 n12 {59629954205310710000/19732474640252003}
R12_0 n12 n13 {4025430480249037/5000000000000000000}
C12_1 n12 n13 {15130632534632642000/4025430480249037}
R13_0 n13 portn {5937285183254797/5000000000000000000}
C13_1 n13 portn {38392791668066385000/5937285183254797}
.ends NONAGON_POSITIVE_REAL
