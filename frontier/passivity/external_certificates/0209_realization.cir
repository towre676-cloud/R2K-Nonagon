* Exact decimal-rational passive realization; s=+i*2*pi*f_hz
.subckt NONAGON_POSITIVE_REAL portp portn
R0_0 portp n1 {6977315874421031/500000000000000000}
L1_0 n1 n2 {9288862976299583/100000000000000000000000}
R2_0 n2 n3 {775363023080177/500000000000000000}
C2_1 n2 n3 {2735023091892717/15507260461603540}
R3_0 n3 n4 {5802798839763453/5000000000000000000}
C3_1 n3 n4 {6939906281779079/11605597679526906}
R4_0 n4 n5 {3951012017543059/5000000000000000000}
C4_1 n4 n5 {8804733558309190/3951012017543059}
R5_0 n5 n6 {126457935953433/312500000000000000}
C5_1 n5 n6 {22341319863743875/2023326975254928}
R6_0 n6 n7 {4032671777563071/500000000000000000000}
C6_1 n6 n7 {5668934442463328500/4032671777563071}
R7_0 n7 n8 {12182476075613901/100000000000000000000}
C7_1 n7 n8 {319655019975387600/1353608452845989}
R8_0 n8 n9 {10368600204497633/100000000000000000000}
C8_1 n8 n9 {1042842223126639000/1481228600642519}
R9_0 n9 n10 {1026445935507607/5000000000000000000}
C9_1 n9 n10 {926145582032519150/1026445935507607}
R10_0 n10 n11 {4859289295288591/20000000000000000000}
C10_1 n10 n11 {9400086692710866000/4859289295288591}
R11_0 n11 n12 {692500880520229/1000000000000000000}
C11_1 n11 n12 {1192599084106214200/692500880520229}
R12_0 n12 n13 {1978517072395469/500000000000000000}
C12_1 n12 n13 {3839279166806638500/1978517072395469}
R13_0 n13 portn {4162900070638567/2500000000000000000}
C13_1 n13 portn {48709346707537975000/4162900070638567}
.ends NONAGON_POSITIVE_REAL
