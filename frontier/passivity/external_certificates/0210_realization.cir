* Exact decimal-rational passive realization; s=+i*2*pi*f_hz
.subckt NONAGON_POSITIVE_REAL portp portn
R0_0 portp n1 {3491049060757023/250000000000000000}
L1_0 n1 n2 {4629916430373019/50000000000000000000000}
R2_0 n2 n3 {7753301444456713/5000000000000000000}
C2_1 n2 n3 {2735023091892717/15506602888913426}
R3_0 n3 n4 {5244281751794901/5000000000000000000}
C3_1 n3 n4 {6939906281779079/10488563503589802}
R4_0 n4 n5 {5067110055537677/5000000000000000000}
C4_1 n4 n5 {8804733558309190/5067110055537677}
R5_0 n5 n6 {76615201208859/200000000000000000}
C5_1 n5 n6 {893652794549755/76615201208859}
R6_0 n6 n7 {3412404872151741/20000000000000000000}
C6_1 n6 n7 {1459979112377294600/3412404872151741}
R7_0 n7 n8 {13778416079497259/100000000000000000000}
C7_1 n7 n8 {18522911640650383000/13778416079497259}
R8_0 n8 n9 {51293925820727/156250000000000000}
C8_1 n8 n9 {587505418294429125/410351406565816}
R9_0 n9 n10 {1546452072006637/2500000000000000000}
C9_1 n9 n10 {2981497710265535500/1546452072006637}
R10_0 n10 n11 {159973461028719/40000000000000000}
C10_1 n10 n11 {34126925927170120/17774829003191}
R11_0 n11 portn {850346349280483/500000000000000000}
C11_1 n11 portn {9741869341507595000/850346349280483}
.ends NONAGON_POSITIVE_REAL
