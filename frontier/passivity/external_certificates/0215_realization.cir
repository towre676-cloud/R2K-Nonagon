* Exact decimal-rational passive realization; s=+i*2*pi*f_hz
.subckt NONAGON_POSITIVE_REAL portp portn
R0_0 portp n1 {13542382512579089/1000000000000000000}
L1_0 n1 n2 {186584575997263/2000000000000000000000}
R2_0 n2 n3 {901667421300771/500000000000000000}
C2_1 n2 n3 {911674363964239/6011116142005140}
R3_0 n3 n4 {8778407186654821/10000000000000000000}
C3_1 n3 n4 {6939906281779079/8778407186654821}
R4_0 n4 n5 {5574465183991813/5000000000000000000}
C4_1 n4 n5 {8804733558309190/5574465183991813}
R5_0 n5 n6 {1838694387367849/5000000000000000000}
C5_1 n5 n6 {22341319863743875/1838694387367849}
R6_0 n6 n7 {4436110887869703/20000000000000000000}
C6_1 n6 n7 {208568444625327800/633730126838529}
R7_0 n7 n8 {1626651441061963/25000000000000000000}
C7_1 n7 n8 {4630727910162595750/1626651441061963}
R8_0 n8 n9 {7364588834158761/20000000000000000000}
C8_1 n8 n9 {3133362230903622000/2454862944719587}
R9_0 n9 n10 {6365886237906123/10000000000000000000}
C9_1 n9 n10 {11925990841062142000/6365886237906123}
R10_0 n10 n11 {17974996657381863/5000000000000000000}
C10_1 n10 n11 {387805976445115000/181565622801837}
R11_0 n11 portn {12630733842620577/5000000000000000000}
C11_1 n11 portn {5127299653425050000/664775465401083}
.ends NONAGON_POSITIVE_REAL
