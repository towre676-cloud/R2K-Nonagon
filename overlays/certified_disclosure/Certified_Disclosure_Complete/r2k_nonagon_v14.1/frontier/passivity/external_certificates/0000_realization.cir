* Exact decimal-rational passive realization; s=+i*2*pi*f_hz
.subckt NONAGON_POSITIVE_REAL portp portn
R0_0 portp n1 {13909679772464777/1000000000000000000}
L1_0 n1 n2 {1167328748329039/12500000000000000000000}
R2_0 n2 n3 {178994885942847/125000000000000000}
C2_1 n2 n3 {911674363964239/4773196958475920}
R3_0 n3 n4 {3451917582756319/2500000000000000000}
C3_1 n3 n4 {6939906281779079/13807670331025276}
R4_0 n4 n5 {1022141749389937/1250000000000000000}
C4_1 n4 n5 {4402366779154595/2044283498779874}
R5_0 n5 n6 {554597731056911/1250000000000000000}
C5_1 n5 n6 {17146062827125/1702525651748}
R6_0 n6 n7 {9300495440205757/1000000000000000000000}
C6_1 n6 n7 {11337868884926657000/9300495440205757}
R7_0 n7 n8 {906172822758509/6250000000000000000}
C7_1 n7 n8 {179805948736155525/906172822758509}
R8_0 n8 n9 {4211087913697537/50000000000000000000}
C8_1 n8 n9 {3649947780943236500/4211087913697537}
R9_0 n9 n10 {1487818586887041/10000000000000000000}
C9_1 n9 n10 {1852291164065038300/1487818586887041}
R10_0 n10 n11 {4334858694466343/12500000000000000000}
C10_1 n10 n11 {5875054182944291250/4334858694466343}
R11_0 n11 n12 {5659982678841703/10000000000000000000}
C11_1 n11 n12 {11925990841062142000/5659982678841703}
R12_0 n12 n13 {979893948867783/250000000000000000}
C12_1 n12 n13 {639879861134439750/326631316289261}
R13_0 n13 portn {1019416661564109/500000000000000000}
C13_1 n13 portn {9741869341507595000/1019416661564109}
.ends NONAGON_POSITIVE_REAL
