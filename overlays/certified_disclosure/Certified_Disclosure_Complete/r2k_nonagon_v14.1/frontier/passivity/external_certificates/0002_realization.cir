* Exact decimal-rational passive realization; s=+i*2*pi*f_hz
.subckt NONAGON_POSITIVE_REAL portp portn
R0_0 portp n1 {6937486444204167/500000000000000000}
L1_0 n1 n2 {9359459281948311/100000000000000000000000}
R2_0 n2 n3 {15552296620999077/10000000000000000000}
C2_1 n2 n3 {911674363964239/5184098873666359}
R3_0 n3 n4 {92528199179001/78125000000000000}
C3_1 n3 n4 {6939906281779079/11843609494912128}
R4_0 n4 n5 {2439803197497891/2500000000000000000}
C4_1 n4 n5 {4402366779154595/2439803197497891}
R5_0 n5 n6 {4912882165804757/10000000000000000000}
C5_1 n5 n6 {44682639727487750/4912882165804757}
R6_0 n6 n7 {18299574198794193/100000000000000000000}
C6_1 n6 n7 {7299895561886473000/18299574198794193}
R7_0 n7 n8 {2219584755355191/20000000000000000000}
C7_1 n7 n8 {3704582328130076600/2219584755355191}
R8_0 n8 n9 {408255194138443/1250000000000000000}
C8_1 n8 n9 {587505418294429125/408255194138443}
R9_0 n9 n10 {6206505712921009/10000000000000000000}
C9_1 n9 n10 {11925990841062142000/6206505712921009}
R10_0 n10 n11 {3585159524343637/1000000000000000000}
C10_1 n10 n11 {7678558333613277000/3585159524343637}
R11_0 n11 portn {26930411163835527/10000000000000000000}
C11_1 n11 portn {194837386830151900000/26930411163835527}
.ends NONAGON_POSITIVE_REAL
