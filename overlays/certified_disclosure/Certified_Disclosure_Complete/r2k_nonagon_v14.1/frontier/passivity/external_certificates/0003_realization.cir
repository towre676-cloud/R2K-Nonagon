* Exact decimal-rational passive realization; s=+i*2*pi*f_hz
.subckt NONAGON_POSITIVE_REAL portp portn
R0_0 portp n1 {3461278767487383/250000000000000000}
L1_0 n1 n2 {2351677777812861/25000000000000000000000}
R2_0 n2 n3 {16292569235875983/10000000000000000000}
C2_1 n2 n3 {911674363964239/5430856411958661}
R3_0 n3 n4 {2801415237891023/2500000000000000000}
C3_1 n3 n4 {6939906281779079/11205660951564092}
R4_0 n4 n5 {1209719751386963/1250000000000000000}
C4_1 n4 n5 {4402366779154595/2419439502773926}
R5_0 n5 n6 {517402704753391/1000000000000000000}
C5_1 n5 n6 {4468263972748775/517402704753391}
R6_0 n6 n7 {18609346811225333/100000000000000000000}
C6_1 n6 n7 {7299895561886473000/18609346811225333}
R7_0 n7 n8 {576877376141097/5000000000000000000}
C7_1 n7 n8 {926145582032519150/576877376141097}
R8_0 n8 n9 {1479629263558029/5000000000000000000}
C8_1 n8 n9 {783340557725905500/493209754519343}
R9_0 n9 n10 {6715357811440799/10000000000000000000}
C9_1 n9 n10 {11925990841062142000/6715357811440799}
R10_0 n10 n11 {17153108496100833/5000000000000000000}
C10_1 n10 n11 {12797597222688795000/5717702832033611}
R11_0 n11 portn {2926382182826217/1000000000000000000}
C11_1 n11 portn {19483738683015190000/2926382182826217}
.ends NONAGON_POSITIVE_REAL
