* Exact decimal-rational passive realization; s=+i*2*pi*f_hz
.subckt NONAGON_POSITIVE_REAL portp portn
R0_0 portp n1 {3505570731713709/250000000000000000}
L1_0 n1 n2 {1180905682566649/12500000000000000000000}
R2_0 n2 n3 {3504770816932129/2000000000000000000}
C2_1 n2 n3 {2735023091892717/17523854084660645}
R3_0 n3 n4 {9699616560606703/10000000000000000000}
C3_1 n3 n4 {6939906281779079/9699616560606703}
R4_0 n4 n5 {13763838950527803/10000000000000000000}
C4_1 n4 n5 {17609467116618380/13763838950527803}
R5_0 n5 n6 {1406087602824363/4000000000000000000}
C5_1 n5 n6 {17873055890995100/1406087602824363}
R6_0 n6 n7 {1929456206914129/10000000000000000000}
C6_1 n6 n7 {729989556188647300/1929456206914129}
R7_0 n7 n8 {11036487776354531/100000000000000000000}
C7_1 n7 n8 {18522911640650383000/11036487776354531}
R8_0 n8 n9 {15663319817436143/50000000000000000000}
C8_1 n8 n9 {23500216731777165000/15663319817436143}
R9_0 n9 n10 {6440869633476997/10000000000000000000}
C9_1 n9 n10 {11925990841062142000/6440869633476997}
R10_0 n10 n11 {16201902981344263/5000000000000000000}
C10_1 n10 n11 {38392791668066385000/16201902981344263}
R11_0 n11 portn {34595821038782217/10000000000000000000}
C11_1 n11 portn {194837386830151900000/34595821038782217}
.ends NONAGON_POSITIVE_REAL
