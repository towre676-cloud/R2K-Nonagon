* Exact decimal-rational passive realization; s=+i*2*pi*f_hz
.subckt NONAGON_POSITIVE_REAL portp portn
R0_0 portp n1 {6825936711307821/500000000000000000}
L1_0 n1 n2 {1832512197922463/20000000000000000000000}
R2_0 n2 n3 {18320640887795863/10000000000000000000}
C2_1 n2 n3 {2735023091892717/18320640887795863}
R3_0 n3 n4 {639891062319259/625000000000000000}
C3_1 n3 n4 {6939906281779079/10238256997108144}
R4_0 n4 n5 {12584273721251427/10000000000000000000}
C4_1 n4 n5 {17609467116618380/12584273721251427}
R5_0 n5 n6 {1576027138712793/5000000000000000000}
C5_1 n5 n6 {22341319863743875/1576027138712793}
R6_0 n6 n7 {14021392916747783/100000000000000000000}
C6_1 n6 n7 {1133786888492665700/14021392916747783}
R7_0 n7 n8 {3236207964865483/100000000000000000000}
C7_1 n7 n8 {2876895179778488400/3236207964865483}
R8_0 n8 n9 {8287516833549323/50000000000000000000}
C8_1 n8 n9 {3649947780943236500/8287516833549323}
R9_0 n9 n10 {248946966325459/2000000000000000000}
C9_1 n9 n10 {370458232813007660/248946966325459}
R10_0 n10 n11 {157724354119/500000000000000}
C10_1 n10 n11 {4700043346355433/3154487082380}
R11_0 n11 n12 {5900715057049487/10000000000000000000}
C11_1 n11 n12 {11925990841062142000/5900715057049487}
R12_0 n12 n13 {5685279383476577/20000000000000000000}
C12_1 n12 n13 {60522530138530568000/5685279383476577}
R13_0 n13 n14 {4349706092525189/2000000000000000000}
C13_1 n13 n14 {1396101515202414000/395427826593199}
R14_0 n14 portn {160233560088871/31250000000000000}
C14_1 n14 portn {1217733667688449375/320467120177742}
.ends NONAGON_POSITIVE_REAL
