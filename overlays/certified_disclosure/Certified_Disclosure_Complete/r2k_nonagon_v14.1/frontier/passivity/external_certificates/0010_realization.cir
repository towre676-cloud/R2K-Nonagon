* Exact decimal-rational passive realization; s=+i*2*pi*f_hz
.subckt NONAGON_POSITIVE_REAL portp portn
R0_0 portp n1 {13652283647302721/1000000000000000000}
L1_0 n1 n2 {914718913248353/10000000000000000000000}
R2_0 n2 n3 {2321555185544757/1250000000000000000}
C2_1 n2 n3 {911674363964239/6190813828119352}
R3_0 n3 n4 {55401282849687/62500000000000000}
C3_1 n3 n4 {6939906281779079/8864205255949920}
R4_0 n4 n5 {14953131232664787/10000000000000000000}
C4_1 n4 n5 {17609467116618380/14953131232664787}
R5_0 n5 n6 {2062797589536599/6250000000000000000}
C5_1 n5 n6 {111706599318719375/8251190358146396}
R6_0 n6 n7 {1044299628184011/50000000000000000000}
C6_1 n6 n7 {479482529963081400/348099876061337}
R7_0 n7 n8 {3871885401590483/20000000000000000000}
C7_1 n7 n8 {1459979112377294600/3871885401590483}
R8_0 n8 n9 {5452848622914221/50000000000000000000}
C8_1 n8 n9 {9261455820325191500/5452848622914221}
R9_0 n9 n10 {6210588957020147/20000000000000000000}
C9_1 n9 n10 {9400086692710866000/6210588957020147}
R10_0 n10 n11 {6297169642560127/10000000000000000000}
C10_1 n10 n11 {11925990841062142000/6297169642560127}
R11_0 n11 n12 {534629416416381/5000000000000000000}
C11_1 n11 n12 {15130632534632642000/534629416416381}
R12_0 n12 n13 {2698641876775393/1000000000000000000}
C12_1 n12 n13 {7678558333613277000/2698641876775393}
R13_0 n13 portn {222982121386731/50000000000000000}
C13_1 n13 portn {974186934150759500/222982121386731}
.ends NONAGON_POSITIVE_REAL
