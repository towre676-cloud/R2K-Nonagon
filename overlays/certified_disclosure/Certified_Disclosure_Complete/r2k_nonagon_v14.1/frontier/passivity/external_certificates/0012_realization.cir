* Exact decimal-rational passive realization; s=+i*2*pi*f_hz
.subckt NONAGON_POSITIVE_REAL portp portn
R0_0 portp n1 {13562330474687651/1000000000000000000}
L1_0 n1 n2 {141241135848403/1562500000000000000000}
R2_0 n2 n3 {885886221353623/500000000000000000}
C2_1 n2 n3 {2735023091892717/17717724427072460}
R3_0 n3 n4 {5663773019769173/5000000000000000000}
C3_1 n3 n4 {6939906281779079/11327546039538346}
R4_0 n4 n5 {6389127827444571/5000000000000000000}
C4_1 n4 n5 {8804733558309190/6389127827444571}
R5_0 n5 n6 {16645265901895273/50000000000000000000}
C5_1 n5 n6 {223413198637438750/16645265901895273}
R6_0 n6 n7 {17379416189009327/100000000000000000000}
C6_1 n6 n7 {1133786888492665700/17379416189009327}
R7_0 n7 n8 {6589205411925679/100000000000000000000}
C7_1 n7 n8 {2876895179778488400/6589205411925679}
R8_0 n8 n9 {824227044325151/6250000000000000000}
C8_1 n8 n9 {912486945235809125/1648454088650302}
R9_0 n9 n10 {8940358070848279/50000000000000000000}
C9_1 n9 n10 {9261455820325191500/8940358070848279}
R10_0 n10 n11 {24542616840543573/100000000000000000000}
C10_1 n10 n11 {15666811154518110000/8180872280181191}
R11_0 n11 n12 {7189013320861047/10000000000000000000}
C11_1 n11 n12 {917383910850934000/553001024681619}
R12_0 n12 n13 {21210047394793633/10000000000000000000}
C12_1 n12 n13 {76785583336132770000/21210047394793633}
R13_0 n13 portn {5930899729137047/1000000000000000000}
C13_1 n13 portn {19483738683015190000/5930899729137047}
.ends NONAGON_POSITIVE_REAL
