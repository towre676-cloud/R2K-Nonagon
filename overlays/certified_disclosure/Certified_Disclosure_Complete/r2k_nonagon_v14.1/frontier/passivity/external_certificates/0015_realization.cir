* Exact decimal-rational passive realization; s=+i*2*pi*f_hz
.subckt NONAGON_POSITIVE_REAL portp portn
R0_0 portp n1 {6751269443925417/500000000000000000}
L1_0 n1 n2 {9089849330525503/100000000000000000000000}
R2_0 n2 n3 {19683542705737247/10000000000000000000}
C2_1 n2 n3 {2735023091892717/19683542705737247}
R3_0 n3 n4 {8425248101257693/10000000000000000000}
C3_1 n3 n4 {6939906281779079/8425248101257693}
R4_0 n4 n5 {7272763870416703/5000000000000000000}
C4_1 n4 n5 {8804733558309190/7272763870416703}
R5_0 n5 n6 {5050845352482541/10000000000000000000}
C5_1 n5 n6 {44682639727487750/5050845352482541}
R6_0 n6 n7 {3313962254803031/250000000000000000000}
C6_1 n6 n7 {7192237949446221000/3313962254803031}
R7_0 n7 n8 {10723334063475549/50000000000000000000}
C7_1 n7 n8 {3649947780943236500/10723334063475549}
R8_0 n8 n9 {4904322900558691/50000000000000000000}
C8_1 n8 n9 {9261455820325191500/4904322900558691}
R9_0 n9 n10 {6561103470286299/20000000000000000000}
C9_1 n9 n10 {3133362230903622000/2187034490095433}
R10_0 n10 n11 {5632865197088401/10000000000000000000}
C10_1 n10 n11 {11925990841062142000/5632865197088401}
R11_0 n11 n12 {5418908652623063/10000000000000000000}
C11_1 n11 n12 {30261265069265284000/5418908652623063}
R12_0 n12 n13 {31941310680665103/100000000000000000000}
C12_1 n12 n13 {255951944453775900000/10647103560221701}
R13_0 n13 portn {85058909077839/10000000000000000}
C13_1 n13 portn {194837386830151900/85058909077839}
.ends NONAGON_POSITIVE_REAL
