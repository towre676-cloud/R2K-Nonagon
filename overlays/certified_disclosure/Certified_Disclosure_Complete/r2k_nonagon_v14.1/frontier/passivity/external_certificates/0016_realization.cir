* Exact decimal-rational passive realization; s=+i*2*pi*f_hz
.subckt NONAGON_POSITIVE_REAL portp portn
R0_0 portp n1 {1693386982891999/125000000000000000}
L1_0 n1 n2 {579213027079693/6250000000000000000000}
R2_0 n2 n3 {3486461552046083/2000000000000000000}
C2_1 n2 n3 {2735023091892717/17432307760230415}
R3_0 n3 n4 {2796170078084117/2500000000000000000}
C3_1 n3 n4 {991415183111297/1597811473190924}
R4_0 n4 n5 {5978540129107033/5000000000000000000}
C4_1 n4 n5 {8804733558309190/5978540129107033}
R5_0 n5 n6 {311093195434451/1000000000000000000}
C5_1 n5 n6 {4468263972748775/311093195434451}
R6_0 n6 n7 {8478085604928643/50000000000000000000}
C6_1 n6 n7 {566893444246332850/8478085604928643}
R7_0 n7 n8 {6290965861261597/125000000000000000000}
C7_1 n7 n8 {3596118974723110500/6290965861261597}
R8_0 n8 n9 {1466423530156297/10000000000000000000}
C8_1 n8 n9 {729989556188647300/1466423530156297}
R9_0 n9 n10 {12122574298485469/100000000000000000000}
C9_1 n9 n10 {18522911640650383000/12122574298485469}
R10_0 n10 n11 {33421712600208533/100000000000000000000}
C10_1 n10 n11 {47000433463554330000/33421712600208533}
R11_0 n11 n12 {2961062936267039/5000000000000000000}
C11_1 n11 n12 {5962995420531071000/2961062936267039}
R12_0 n12 n13 {35049157433013787/10000000000000000000}
C12_1 n12 n13 {76785583336132770000/35049157433013787}
R13_0 n13 portn {93094822461909/31250000000000000}
C13_1 n13 portn {1217733667688449375/186189644923818}
.ends NONAGON_POSITIVE_REAL
