* Exact decimal-rational passive realization; s=+i*2*pi*f_hz
.subckt NONAGON_POSITIVE_REAL portp portn
R0_0 portp n1 {13510447973261643/1000000000000000000}
L1_0 n1 n2 {1860830502531817/20000000000000000000000}
R2_0 n2 n3 {18851407077755597/10000000000000000000}
C2_1 n2 n3 {2735023091892717/18851407077755597}
R3_0 n3 n4 {9312175026570683/10000000000000000000}
C3_1 n3 n4 {6939906281779079/9312175026570683}
R4_0 n4 n5 {13089247874277423/10000000000000000000}
C4_1 n4 n5 {17609467116618380/13089247874277423}
R5_0 n5 n6 {27971366137781407/100000000000000000000}
C5_1 n5 n6 {446826397274877500/27971366137781407}
R6_0 n6 n7 {1740496233258233/10000000000000000000}
C6_1 n6 n7 {113378688849266570/1740496233258233}
R7_0 n7 n8 {148805093244307/3125000000000000000}
C7_1 n7 n8 {179805948736155525/297610186488614}
R8_0 n8 n9 {13106740013874469/100000000000000000000}
C8_1 n8 n9 {7299895561886473000/13106740013874469}
R9_0 n9 n10 {4310485925368917/25000000000000000000}
C9_1 n9 n10 {4630727910162595750/4310485925368917}
R10_0 n10 n11 {610488049798873/2500000000000000000}
C10_1 n10 n11 {1175010836588858250/610488049798873}
R11_0 n11 n12 {139995042491853/200000000000000000}
C11_1 n11 n12 {238519816821242840/139995042491853}
R12_0 n12 n13 {31301362275646047/10000000000000000000}
C12_1 n12 n13 {25595194445377590000/10433787425215349}
R13_0 n13 portn {3635801903088081/1000000000000000000}
C13_1 n13 portn {19483738683015190000/3635801903088081}
.ends NONAGON_POSITIVE_REAL
