* Exact decimal-rational passive realization; s=+i*2*pi*f_hz
.subckt NONAGON_POSITIVE_REAL portp portn
R0_0 portp n1 {2702332792807421/200000000000000000}
L1_0 n1 n2 {9276811228061011/100000000000000000000000}
R2_0 n2 n3 {19190066021430073/10000000000000000000}
C2_1 n2 n3 {2735023091892717/19190066021430073}
R3_0 n3 n4 {7587181030840243/10000000000000000000}
C3_1 n3 n4 {991415183111297/1083883004405749}
R4_0 n4 n5 {16040800610961949/10000000000000000000}
C4_1 n4 n5 {374669513119540/341293630020467}
R5_0 n5 n6 {383708269605051/1250000000000000000}
C5_1 n5 n6 {22341319863743875/1534833078420204}
R6_0 n6 n7 {1121526738568261/5000000000000000000}
C6_1 n6 n7 {364994778094323650/1121526738568261}
R7_0 n7 n8 {7387671646431161/100000000000000000000}
C7_1 n7 n8 {18522911640650383000/7387671646431161}
R8_0 n8 n9 {33418626882001333/100000000000000000000}
C8_1 n8 n9 {47000433463554330000/33418626882001333}
R9_0 n9 n10 {1597282985078211/2500000000000000000}
C9_1 n9 n10 {2981497710265535500/1597282985078211}
R10_0 n10 n11 {391271444731561/125000000000000000}
C10_1 n10 n11 {959819791701659625/391271444731561}
R11_0 n11 portn {3732455562063183/1000000000000000000}
C11_1 n11 portn {19483738683015190000/3732455562063183}
.ends NONAGON_POSITIVE_REAL
