* Exact decimal-rational passive realization; s=+i*2*pi*f_hz
.subckt NONAGON_POSITIVE_REAL portp portn
R0_0 portp n1 {849346168530879/62500000000000000}
L1_0 n1 n2 {4615800593973/50000000000000000000}
R2_0 n2 n3 {1915212101773617/1000000000000000000}
C2_1 n2 n3 {911674363964239/6384040339245390}
R3_0 n3 n4 {9860499920558723/10000000000000000000}
C3_1 n3 n4 {6939906281779079/9860499920558723}
R4_0 n4 n5 {3438880975941811/2500000000000000000}
C4_1 n4 n5 {4402366779154595/3438880975941811}
R5_0 n5 n6 {1621910504363639/5000000000000000000}
C5_1 n5 n6 {22341319863743875/1621910504363639}
R6_0 n6 n7 {14687233712750821/100000000000000000000}
C6_1 n6 n7 {1133786888492665700/14687233712750821}
R7_0 n7 n8 {1217105045202071/20000000000000000000}
C7_1 n7 n8 {575379035955697680/1217105045202071}
R8_0 n8 n9 {6966513796992729/50000000000000000000}
C8_1 n8 n9 {521421111563319500/995216256713247}
R9_0 n9 n10 {8807656404093531/50000000000000000000}
C9_1 n9 n10 {9261455820325191500/8807656404093531}
R10_0 n10 n11 {496235686070759/2000000000000000000}
C10_1 n10 n11 {940008669271086600/496235686070759}
R11_0 n11 n12 {351738803089671/500000000000000000}
C11_1 n11 n12 {596299542053107100/351738803089671}
R12_0 n12 n13 {10752084851819263/100000000000000000000}
C12_1 n12 n13 {302612650692652840000/10752084851819263}
R13_0 n13 n14 {2262248386761211/1000000000000000000}
C13_1 n13 n14 {7678558333613277000/2262248386761211}
R14_0 n14 portn {5362697033713497/1000000000000000000}
C14_1 n14 portn {19483738683015190000/5362697033713497}
.ends NONAGON_POSITIVE_REAL
