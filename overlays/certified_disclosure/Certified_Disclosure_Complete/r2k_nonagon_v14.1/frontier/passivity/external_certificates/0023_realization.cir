* Exact decimal-rational passive realization; s=+i*2*pi*f_hz
.subckt NONAGON_POSITIVE_REAL portp portn
R0_0 portp n1 {13563672791049997/1000000000000000000}
L1_0 n1 n2 {4621867244749981/50000000000000000000000}
R2_0 n2 n3 {3984735328568273/2000000000000000000}
C2_1 n2 n3 {2735023091892717/19923676642841365}
R3_0 n3 n4 {4157978726770783/5000000000000000000}
C3_1 n3 n4 {6939906281779079/8315957453541566}
R4_0 n4 n5 {7797050324066839/5000000000000000000}
C4_1 n4 n5 {8804733558309190/7797050324066839}
R5_0 n5 n6 {39843100425095753/100000000000000000000}
C5_1 n5 n6 {446826397274877500/39843100425095753}
R6_0 n6 n7 {26543153019292783/1000000000000000000000}
C6_1 n6 n7 {28768951797784884000/26543153019292783}
R7_0 n7 n8 {10988201775109407/50000000000000000000}
C7_1 n7 n8 {3649947780943236500/10988201775109407}
R8_0 n8 n9 {4050545583672279/50000000000000000000}
C8_1 n8 n9 {9261455820325191500/4050545583672279}
R9_0 n9 n10 {32787360206126007/100000000000000000000}
C9_1 n9 n10 {15666811154518110000/10929120068708669}
R10_0 n10 n11 {6375940311906013/10000000000000000000}
C10_1 n10 n11 {11925990841062142000/6375940311906013}
R11_0 n11 n12 {177098734573141/800000000000000000}
C11_1 n11 n12 {2420901205541222720/177098734573141}
R12_0 n12 n13 {18905138425557857/10000000000000000000}
C12_1 n12 n13 {6980507576012070000/1718648947777987}
R13_0 n13 portn {592529800156519/100000000000000000}
C13_1 n13 portn {1948373868301519000/592529800156519}
.ends NONAGON_POSITIVE_REAL
