* Exact decimal-rational passive realization; s=+i*2*pi*f_hz
.subckt NONAGON_POSITIVE_REAL portp portn
R0_0 portp n1 {7122912951764819/500000000000000000}
L1_0 n1 n2 {471597075844421/5000000000000000000000}
R2_0 n2 n3 {811622537925147/500000000000000000}
C2_1 n2 n3 {911674363964239/5410816919500980}
R3_0 n3 n4 {2750599856031041/2000000000000000000}
C3_1 n3 n4 {141630740444471/280673454697045}
R4_0 n4 n5 {5897209568501697/5000000000000000000}
C4_1 n4 n5 {8804733558309190/5897209568501697}
R5_0 n5 n6 {11094118814368979/25000000000000000000}
C5_1 n5 n6 {111706599318719375/11094118814368979}
R6_0 n6 n7 {14896742819380887/100000000000000000000}
C6_1 n6 n7 {1133786888492665700/14896742819380887}
R7_0 n7 n8 {7691723441976903/100000000000000000000}
C7_1 n7 n8 {19570715508697200/52324649265149}
R8_0 n8 n9 {61159592158467/400000000000000000}
C8_1 n8 n9 {29199582247545892/61159592158467}
R9_0 n9 n10 {2637090293859103/20000000000000000000}
C9_1 n9 n10 {3704582328130076600/2637090293859103}
R10_0 n10 n11 {61360434292677/200000000000000000}
C10_1 n10 n11 {31333622309036220/20453478097559}
R11_0 n11 n12 {6713122869449167/10000000000000000000}
C11_1 n11 n12 {11925990841062142000/6713122869449167}
R12_0 n12 n13 {1384139547784229/500000000000000000}
C12_1 n12 n13 {3839279166806638500/1384139547784229}
R13_0 n13 portn {2355795650608079/500000000000000000}
C13_1 n13 portn {9741869341507595000/2355795650608079}
.ends NONAGON_POSITIVE_REAL
