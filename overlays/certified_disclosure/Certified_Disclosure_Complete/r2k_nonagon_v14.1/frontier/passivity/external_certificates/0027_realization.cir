* Exact decimal-rational passive realization; s=+i*2*pi*f_hz
.subckt NONAGON_POSITIVE_REAL portp portn
R0_0 portp n1 {14178878368423421/1000000000000000000}
L1_0 n1 n2 {4747454764515927/50000000000000000000000}
R2_0 n2 n3 {18407506294341887/10000000000000000000}
C2_1 n2 n3 {2735023091892717/18407506294341887}
R3_0 n3 n4 {5362463061230141/5000000000000000000}
C3_1 n3 n4 {6939906281779079/10724926122460282}
R4_0 n4 n5 {1354088331095573/1000000000000000000}
C4_1 n4 n5 {1760946711661838/1354088331095573}
R5_0 n5 n6 {6101868238678117/10000000000000000000}
C5_1 n5 n6 {44682639727487750/6101868238678117}
R6_0 n6 n7 {2294617447418451/10000000000000000000}
C6_1 n6 n7 {729989556188647300/2294617447418451}
R7_0 n7 n8 {952450297977221/10000000000000000000}
C7_1 n7 n8 {1852291164065038300/952450297977221}
R8_0 n8 n9 {29992412647423817/100000000000000000000}
C8_1 n8 n9 {47000433463554330000/29992412647423817}
R9_0 n9 n10 {1693918582812181/2500000000000000000}
C9_1 n9 n10 {2981497710265535500/1693918582812181}
R10_0 n10 n11 {18412940270203413/100000000000000000000}
C10_1 n10 n11 {302612650692652840000/18412940270203413}
R11_0 n11 n12 {3741795428729417/2000000000000000000}
C11_1 n11 n12 {15357116667226554000/3741795428729417}
R12_0 n12 portn {1532662332131959/250000000000000000}
C12_1 n12 portn {256364982671252500/80666438533261}
.ends NONAGON_POSITIVE_REAL
