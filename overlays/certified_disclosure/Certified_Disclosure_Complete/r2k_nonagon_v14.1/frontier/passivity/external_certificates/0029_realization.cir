* Exact decimal-rational passive realization; s=+i*2*pi*f_hz
.subckt NONAGON_POSITIVE_REAL portp portn
R0_0 portp n1 {13564829146249817/1000000000000000000}
L1_0 n1 n2 {4438045438383583/50000000000000000000000}
R2_0 n2 n3 {198574441988693/100000000000000000}
C2_1 n2 n3 {2735023091892717/19857444198869300}
R3_0 n3 n4 {469560434353257/500000000000000000}
C3_1 n3 n4 {6939906281779079/9391208687065140}
R4_0 n4 n5 {6004037140429/4000000000000000}
C4_1 n4 n5 {880473355830919/750504642553625}
R5_0 n5 n6 {1658223663839311/5000000000000000000}
C5_1 n5 n6 {22341319863743875/1658223663839311}
R6_0 n6 n7 {9763126978980309/50000000000000000000}
C6_1 n6 n7 {566893444246332850/9763126978980309}
R7_0 n7 n8 {10159579259724577/500000000000000000000}
C7_1 n7 n8 {14384475898892442000/10159579259724577}
R8_0 n8 n9 {1727967178585251/10000000000000000000}
C8_1 n8 n9 {729989556188647300/1727967178585251}
R9_0 n9 n10 {15386494102981503/100000000000000000000}
C9_1 n9 n10 {18522911640650383000/15386494102981503}
R10_0 n10 n11 {26846895094183857/100000000000000000000}
C10_1 n10 n11 {15666811154518110000/8948965031394619}
R11_0 n11 n12 {86294057520683/125000000000000000}
C11_1 n11 n12 {149074885513276775/86294057520683}
R12_0 n12 n13 {6848683927866809/2000000000000000000}
C12_1 n12 n13 {15357116667226554000/6848683927866809}
R13_0 n13 portn {815948929927643/250000000000000000}
C13_1 n13 portn {4870934670753797500/815948929927643}
.ends NONAGON_POSITIVE_REAL
