* Exact decimal-rational passive realization; s=+i*2*pi*f_hz
.subckt NONAGON_POSITIVE_REAL portp portn
R0_0 portp n1 {13614266186357863/1000000000000000000}
L1_0 n1 n2 {913973592965403/10000000000000000000000}
R2_0 n2 n3 {18291585835534731/10000000000000000000}
C2_1 n2 n3 {911674363964239/6097195278511577}
R3_0 n3 n4 {5760062892386169/5000000000000000000}
C3_1 n3 n4 {6939906281779079/11520125784772338}
R4_0 n4 n5 {275299103281441/200000000000000000}
C4_1 n4 n5 {1760946711661838/1376495516407205}
R5_0 n5 n6 {3620153023824613/10000000000000000000}
C5_1 n5 n6 {44682639727487750/3620153023824613}
R6_0 n6 n7 {443326093816149/2500000000000000000}
C6_1 n6 n7 {56689344424633285/886652187632298}
R7_0 n7 n8 {3538239827372033/100000000000000000000}
C7_1 n7 n8 {58712146526091600/72208976068817}
R8_0 n8 n9 {3571908827313937/25000000000000000000}
C8_1 n8 n9 {1824973890471618250/3571908827313937}
R9_0 n9 n10 {1347689877113661/10000000000000000000}
C9_1 n9 n10 {1852291164065038300/1347689877113661}
R10_0 n10 n11 {3143935524407643/10000000000000000000}
C10_1 n10 n11 {522227038483937000/349326169378627}
R11_0 n11 n12 {6153417250471403/10000000000000000000}
C11_1 n11 n12 {11925990841062142000/6153417250471403}
R12_0 n12 n13 {3804209783783557/1000000000000000000}
C12_1 n12 n13 {7678558333613277000/3804209783783557}
R13_0 n13 portn {6305094910035281/2500000000000000000}
C13_1 n13 portn {48709346707537975000/6305094910035281}
.ends NONAGON_POSITIVE_REAL
