* Exact decimal-rational passive realization; s=+i*2*pi*f_hz
.subckt NONAGON_POSITIVE_REAL portp portn
R0_0 portp n1 {677701767128149/50000000000000000}
L1_0 n1 n2 {9191940248285379/100000000000000000000000}
R2_0 n2 n3 {5116123369625329/2500000000000000000}
C2_1 n2 n3 {2735023091892717/20464493478501316}
R3_0 n3 n4 {7791115236858153/10000000000000000000}
C3_1 n3 n4 {6939906281779079/7791115236858153}
R4_0 n4 n5 {887289262194247/500000000000000000}
C4_1 n4 n5 {880473355830919/887289262194247}
R5_0 n5 n6 {2937497800798497/10000000000000000000}
C5_1 n5 n6 {44682639727487750/2937497800798497}
R6_0 n6 n7 {2507878578596609/20000000000000000000}
C6_1 n6 n7 {575379035955697680/2507878578596609}
R7_0 n7 n8 {11008465261573527/100000000000000000000}
C7_1 n7 n8 {7299895561886473000/11008465261573527}
R8_0 n8 n9 {4008220793198321/25000000000000000000}
C8_1 n8 n9 {4630727910162595750/4008220793198321}
R9_0 n9 n10 {27327923135473547/100000000000000000000}
C9_1 n9 n10 {47000433463554330000/27327923135473547}
R10_0 n10 n11 {830835375902209/1250000000000000000}
C10_1 n10 n11 {1490748855132767750/830835375902209}
R11_0 n11 n12 {1799028665841011/500000000000000000}
C11_1 n11 n12 {349025378800603500/163548060531001}
R12_0 n12 portn {5814895636477327/2000000000000000000}
C12_1 n12 portn {38967477366030380000/5814895636477327}
.ends NONAGON_POSITIVE_REAL
