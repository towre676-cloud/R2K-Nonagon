* Exact decimal-rational passive realization; s=+i*2*pi*f_hz
.subckt NONAGON_POSITIVE_REAL portp portn
R0_0 portp n1 {842879813396391/62500000000000000}
L1_0 n1 n2 {4573356987001533/50000000000000000000000}
R2_0 n2 n3 {2310986565839197/1250000000000000000}
C2_1 n2 n3 {2735023091892717/18487892526713576}
R3_0 n3 n4 {2213564612373647/2000000000000000000}
C3_1 n3 n4 {6939906281779079/11067823061868235}
R4_0 n4 n5 {13894250551982187/10000000000000000000}
C4_1 n4 n5 {17609467116618380/13894250551982187}
R5_0 n5 n6 {3455657650766149/10000000000000000000}
C5_1 n5 n6 {44682639727487750/3455657650766149}
R6_0 n6 n7 {10236387710336083/50000000000000000000}
C6_1 n6 n7 {566893444246332850/10236387710336083}
R7_0 n7 n8 {4465781875988551/500000000000000000000}
C7_1 n7 n8 {14384475898892442000/4465781875988551}
R8_0 n8 n9 {193064015775913/1250000000000000000}
C8_1 n8 n9 {182497389047161825/386128031551826}
R9_0 n9 n10 {10156245264877927/100000000000000000000}
C9_1 n9 n10 {18522911640650383000/10156245264877927}
R10_0 n10 n11 {3419931869096843/10000000000000000000}
C10_1 n10 n11 {4700043346355433000/3419931869096843}
R11_0 n11 n12 {5722734151565733/10000000000000000000}
C11_1 n11 n12 {11925990841062142000/5722734151565733}
R12_0 n12 n13 {3989347250952917/1000000000000000000}
C12_1 n12 n13 {7678558333613277000/3989347250952917}
R13_0 n13 portn {827817943466109/400000000000000000}
C13_1 n13 portn {7793495473206076000/827817943466109}
.ends NONAGON_POSITIVE_REAL
