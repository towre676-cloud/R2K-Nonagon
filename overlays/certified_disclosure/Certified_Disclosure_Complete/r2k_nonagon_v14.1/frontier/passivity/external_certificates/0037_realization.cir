* Exact decimal-rational passive realization; s=+i*2*pi*f_hz
.subckt NONAGON_POSITIVE_REAL portp portn
R0_0 portp n1 {6725984276926093/500000000000000000}
L1_0 n1 n2 {9177576117914443/100000000000000000000000}
R2_0 n2 n3 {9893328873728181/5000000000000000000}
C2_1 n2 n3 {911674363964239/6595552582485454}
R3_0 n3 n4 {4605206535204271/5000000000000000000}
C3_1 n3 n4 {6939906281779079/9210413070408542}
R4_0 n4 n5 {15236813208322853/10000000000000000000}
C4_1 n4 n5 {374669513119540/324187515070699}
R5_0 n5 n6 {1488198634951381/5000000000000000000}
C5_1 n5 n6 {22341319863743875/1488198634951381}
R6_0 n6 n7 {2442127231191437/12500000000000000000}
C6_1 n6 n7 {283446722123166425/4884254462382874}
R7_0 n7 n8 {1707614956261037/50000000000000000000}
C7_1 n7 n8 {1438447589889244200/1707614956261037}
R8_0 n8 n9 {63087014669587/500000000000000000}
C8_1 n8 n9 {36499477809432365/63087014669587}
R9_0 n9 n10 {7487427460368853/50000000000000000000}
C9_1 n9 n10 {9261455820325191500/7487427460368853}
R10_0 n10 n11 {5437481546761839/20000000000000000000}
C10_1 n10 n11 {1044454076967874000/604164616306871}
R11_0 n11 n12 {127393963727347/200000000000000000}
C11_1 n11 n12 {238519816821242840/127393963727347}
R12_0 n12 n13 {38346763440127783/10000000000000000000}
C12_1 n12 n13 {76785583336132770000/38346763440127783}
R13_0 n13 portn {23092625063161607/10000000000000000000}
C13_1 n13 portn {194837386830151900000/23092625063161607}
.ends NONAGON_POSITIVE_REAL
