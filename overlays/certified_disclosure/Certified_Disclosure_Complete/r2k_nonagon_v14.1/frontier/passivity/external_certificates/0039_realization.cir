* Exact decimal-rational passive realization; s=+i*2*pi*f_hz
.subckt NONAGON_POSITIVE_REAL portp portn
R0_0 portp n1 {13426615052160187/1000000000000000000}
L1_0 n1 n2 {919407343294607/10000000000000000000000}
R2_0 n2 n3 {5163696583350549/2500000000000000000}
C2_1 n2 n3 {911674363964239/6884928777800732}
R3_0 n3 n4 {228166176121027/312500000000000000}
C3_1 n3 n4 {6939906281779079/7301317635872864}
R4_0 n4 n5 {8974557637974553/5000000000000000000}
C4_1 n4 n5 {8804733558309190/8974557637974553}
R5_0 n5 n6 {2794008498715571/10000000000000000000}
C5_1 n5 n6 {44682639727487750/2794008498715571}
R6_0 n6 n7 {1367846698997757/10000000000000000000}
C6_1 n6 n7 {95896505992616280/455948899665919}
R7_0 n7 n8 {9364622956887383/100000000000000000000}
C7_1 n7 n8 {7299895561886473000/9364622956887383}
R8_0 n8 n9 {2945638224145539/20000000000000000000}
C8_1 n8 n9 {3704582328130076600/2945638224145539}
R9_0 n9 n10 {2827460466388459/10000000000000000000}
C9_1 n9 n10 {4700043346355433000/2827460466388459}
R10_0 n10 n11 {6420063547315137/10000000000000000000}
C10_1 n10 n11 {11925990841062142000/6420063547315137}
R11_0 n11 n12 {928306618098809/250000000000000000}
C11_1 n11 n12 {1919639583403319250/928306618098809}
R12_0 n12 portn {2554741604409089/1000000000000000000}
C12_1 n12 portn {19483738683015190000/2554741604409089}
.ends NONAGON_POSITIVE_REAL
