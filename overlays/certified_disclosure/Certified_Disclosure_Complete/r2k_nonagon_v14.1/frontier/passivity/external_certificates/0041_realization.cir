* Exact decimal-rational passive realization; s=+i*2*pi*f_hz
.subckt NONAGON_POSITIVE_REAL portp portn
R0_0 portp n1 {1379639446206609/100000000000000000}
L1_0 n1 n2 {9318019243982457/100000000000000000000000}
R2_0 n2 n3 {17938669946145243/10000000000000000000}
C2_1 n2 n3 {911674363964239/5979556648715081}
R3_0 n3 n4 {11812530207543723/10000000000000000000}
C3_1 n3 n4 {991415183111297/1687504315363389}
R4_0 n4 n5 {559213950317079/400000000000000000}
C4_1 n4 n5 {3521893423323676/2796069751585395}
R5_0 n5 n6 {22939563467269303/50000000000000000000}
C5_1 n5 n6 {223413198637438750/22939563467269303}
R6_0 n6 n7 {7168341369037949/100000000000000000000}
C6_1 n6 n7 {1133786888492665700/7168341369037949}
R7_0 n7 n8 {1320714994624599/10000000000000000000}
C7_1 n7 n8 {13699500856088040/62891190220219}
R8_0 n8 n9 {2142236182281603/40000000000000000000}
C8_1 n8 n9 {2919958224754589200/2142236182281603}
R9_0 n9 n10 {11228035115846037/50000000000000000000}
C9_1 n9 n10 {9261455820325191500/11228035115846037}
R10_0 n10 n11 {23628635990505297/100000000000000000000}
C10_1 n10 n11 {5222270384839370000/2625403998945033}
R11_0 n11 n12 {132103022310173/200000000000000000}
C11_1 n11 n12 {238519816821242840/132103022310173}
R12_0 n12 n13 {18808965192321347/5000000000000000000}
C12_1 n12 n13 {38392791668066385000/18808965192321347}
R13_0 n13 portn {4961729872563033/2000000000000000000}
C13_1 n13 portn {38967477366030380000/4961729872563033}
.ends NONAGON_POSITIVE_REAL
