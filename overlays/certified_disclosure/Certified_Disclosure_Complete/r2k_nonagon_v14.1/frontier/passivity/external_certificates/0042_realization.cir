* Exact decimal-rational passive realization; s=+i*2*pi*f_hz
.subckt NONAGON_POSITIVE_REAL portp portn
R0_0 portp n1 {3450052436393407/250000000000000000}
L1_0 n1 n2 {186036647321949/2000000000000000000000}
R2_0 n2 n3 {3606493424618341/2000000000000000000}
C2_1 n2 n3 {2735023091892717/18032467123091705}
R3_0 n3 n4 {1351578630214701/1250000000000000000}
C3_1 n3 n4 {991415183111297/1544661291673944}
R4_0 n4 n5 {1013800766740869/625000000000000000}
C4_1 n4 n5 {4402366779154595/4055203066963476}
R5_0 n5 n6 {2224298740172989/5000000000000000000}
C5_1 n5 n6 {22341319863743875/2224298740172989}
R6_0 n6 n7 {1064917074478091/5000000000000000000}
C6_1 n6 n7 {364994778094323650/1064917074478091}
R7_0 n7 n8 {7252772965083687/100000000000000000000}
C7_1 n7 n8 {18522911640650383000/7252772965083687}
R8_0 n8 n9 {372362842249803/1000000000000000000}
C8_1 n8 n9 {52222703848393700/41373649138867}
R9_0 n9 n10 {718340030021799/1250000000000000000}
C9_1 n9 n10 {1490748855132767750/718340030021799}
R10_0 n10 n11 {1918927125140757/500000000000000000}
C10_1 n10 n11 {1279759722268879500/639642375046919}
R11_0 n11 portn {24315118072526713/10000000000000000000}
C11_1 n11 portn {194837386830151900000/24315118072526713}
.ends NONAGON_POSITIVE_REAL
