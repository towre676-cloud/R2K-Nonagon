* Exact decimal-rational passive realization; s=+i*2*pi*f_hz
.subckt NONAGON_POSITIVE_REAL portp portn
R0_0 portp n1 {6885577175236689/500000000000000000}
L1_0 n1 n2 {583835576595449/6250000000000000000000}
R2_0 n2 n3 {1867406868258719/1000000000000000000}
C2_1 n2 n3 {2735023091892717/18674068682587190}
R3_0 n3 n4 {2611969933820101/2500000000000000000}
C3_1 n3 n4 {6939906281779079/10447879735280404}
R4_0 n4 n5 {3155555727739541/2000000000000000000}
C4_1 n4 n5 {3521893423323676/3155555727739541}
R5_0 n5 n6 {574150996453879/1250000000000000000}
C5_1 n5 n6 {720687737540125/74083999542436}
R6_0 n6 n7 {677484727520621/10000000000000000000}
C6_1 n6 n7 {287689517977848840/677484727520621}
R7_0 n7 n8 {7402108493905323/50000000000000000000}
C7_1 n7 n8 {3649947780943236500/7402108493905323}
R8_0 n8 n9 {13176124200462507/100000000000000000000}
C8_1 n8 n9 {18522911640650383000/13176124200462507}
R9_0 n9 n10 {6134626783715827/20000000000000000000}
C9_1 n9 n10 {9400086692710866000/6134626783715827}
R10_0 n10 n11 {3174057637927597/5000000000000000000}
C10_1 n10 n11 {5962995420531071000/3174057637927597}
R11_0 n11 n12 {37079472104560203/10000000000000000000}
C11_1 n11 n12 {25595194445377590000/12359824034853401}
R12_0 n12 portn {1304299308748887/500000000000000000}
C12_1 n12 portn {9741869341507595000/1304299308748887}
.ends NONAGON_POSITIVE_REAL
