* Exact decimal-rational passive realization; s=+i*2*pi*f_hz
.subckt NONAGON_POSITIVE_REAL portp portn
R0_0 portp n1 {173940047747451/12500000000000000}
L1_0 n1 n2 {9190993396157903/100000000000000000000000}
R2_0 n2 n3 {8116631408130573/5000000000000000000}
C2_1 n2 n3 {911674363964239/5411087605420382}
R3_0 n3 n4 {1459331265002407/1000000000000000000}
C3_1 n3 n4 {6939906281779079/14593312650024070}
R4_0 n4 n5 {12177979576147963/10000000000000000000}
C4_1 n4 n5 {17609467116618380/12177979576147963}
R5_0 n5 n6 {5558146866673343/10000000000000000000}
C5_1 n5 n6 {44682639727487750/5558146866673343}
R6_0 n6 n7 {10551942776213573/100000000000000000000}
C6_1 n6 n7 {1133786888492665700/10551942776213573}
R7_0 n7 n8 {8136911768014399/100000000000000000000}
C7_1 n7 n8 {2876895179778488400/8136911768014399}
R8_0 n8 n9 {6418062975196611/50000000000000000000}
C8_1 n8 n9 {3649947780943236500/6418062975196611}
R9_0 n9 n10 {1384028627524389/10000000000000000000}
C9_1 n9 n10 {1852291164065038300/1384028627524389}
R10_0 n10 n11 {918505526064033/3125000000000000000}
C10_1 n10 n11 {979175697157381875/612337017376022}
R11_0 n11 n12 {643359327585717/1000000000000000000}
C11_1 n11 n12 {1192599084106214200/643359327585717}
R12_0 n12 n13 {306298519884557/100000000000000000}
C12_1 n12 n13 {767855833361327700/306298519884557}
R13_0 n13 portn {1018861827287623/250000000000000000}
C13_1 n13 portn {4870934670753797500/1018861827287623}
.ends NONAGON_POSITIVE_REAL
