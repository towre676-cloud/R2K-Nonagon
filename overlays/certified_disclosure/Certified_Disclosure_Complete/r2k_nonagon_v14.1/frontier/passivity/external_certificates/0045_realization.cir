* Exact decimal-rational passive realization; s=+i*2*pi*f_hz
.subckt NONAGON_POSITIVE_REAL portp portn
R0_0 portp n1 {346965381129671/25000000000000000}
L1_0 n1 n2 {2306849934931721/25000000000000000000000}
R2_0 n2 n3 {17586232333395469/10000000000000000000}
C2_1 n2 n3 {2735023091892717/17586232333395469}
R3_0 n3 n4 {6358044034385651/5000000000000000000}
C3_1 n3 n4 {6939906281779079/12716088068771302}
R4_0 n4 n5 {3340727234013027/2500000000000000000}
C4_1 n4 n5 {93667378279885/71079302851341}
R5_0 n5 n6 {5352932692021179/10000000000000000000}
C5_1 n5 n6 {44682639727487750/5352932692021179}
R6_0 n6 n7 {4333011648874353/50000000000000000000}
C6_1 n6 n7 {566893444246332850/4333011648874353}
R7_0 n7 n8 {9740817583984087/100000000000000000000}
C7_1 n7 n8 {2876895179778488400/9740817583984087}
R8_0 n8 n9 {641644500570311/6250000000000000000}
C8_1 n8 n9 {130355277890829875/183327000162946}
R9_0 n9 n10 {18965862087056237/100000000000000000000}
C9_1 n9 n10 {18522911640650383000/18965862087056237}
R10_0 n10 n11 {21326378658239887/100000000000000000000}
C10_1 n10 n11 {47000433463554330000/21326378658239887}
R11_0 n11 n12 {1464824453383659/2000000000000000000}
C11_1 n11 n12 {2385198168212428400/1464824453383659}
R12_0 n12 n13 {7035816526970843/2500000000000000000}
C12_1 n12 n13 {19196395834033192500/7035816526970843}
R13_0 n13 portn {4489218582566401/1000000000000000000}
C13_1 n13 portn {19483738683015190000/4489218582566401}
.ends NONAGON_POSITIVE_REAL
