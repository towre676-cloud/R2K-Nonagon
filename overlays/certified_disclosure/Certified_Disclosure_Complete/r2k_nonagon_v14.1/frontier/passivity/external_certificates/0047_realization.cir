* Exact decimal-rational passive realization; s=+i*2*pi*f_hz
.subckt NONAGON_POSITIVE_REAL portp portn
R0_0 portp n1 {277078000093711/20000000000000000}
L1_0 n1 n2 {115627242775697/1250000000000000000000}
R2_0 n2 n3 {1829855550214071/1000000000000000000}
C2_1 n2 n3 {911674363964239/6099518500713570}
R3_0 n3 n4 {5709020471582997/5000000000000000000}
C3_1 n3 n4 {6939906281779079/11418040943165994}
R4_0 n4 n5 {14861845762127969/10000000000000000000}
C4_1 n4 n5 {17609467116618380/14861845762127969}
R5_0 n5 n6 {5883481037142657/10000000000000000000}
C5_1 n5 n6 {44682639727487750/5883481037142657}
R6_0 n6 n7 {3602951363538967/200000000000000000000}
C6_1 n6 n7 {5753790359556976800/3602951363538967}
R7_0 n7 n8 {10356174734829537/50000000000000000000}
C7_1 n7 n8 {3649947780943236500/10356174734829537}
R8_0 n8 n9 {9658885050048877/100000000000000000000}
C8_1 n8 n9 {18522911640650383000/9658885050048877}
R9_0 n9 n10 {2754031391864919/10000000000000000000}
C9_1 n9 n10 {522227038483937000/306003487984991}
R10_0 n10 n11 {14234887351831/20000000000000000}
C10_1 n10 n11 {23851981682124284/14234887351831}
R11_0 n11 n12 {169540986902743/62500000000000000}
C11_1 n11 n12 {959819791701659625/339081973805486}
R12_0 n12 portn {472888510818299/100000000000000000}
C12_1 n12 portn {1948373868301519000/472888510818299}
.ends NONAGON_POSITIVE_REAL
