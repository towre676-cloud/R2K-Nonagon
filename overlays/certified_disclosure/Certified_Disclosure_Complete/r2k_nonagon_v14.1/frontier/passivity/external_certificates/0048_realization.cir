* Exact decimal-rational passive realization; s=+i*2*pi*f_hz
.subckt NONAGON_POSITIVE_REAL portp portn
R0_0 portp n1 {13700227386471803/1000000000000000000}
L1_0 n1 n2 {9259953601246829/100000000000000000000000}
R2_0 n2 n3 {455473561216039/250000000000000000}
C2_1 n2 n3 {2735023091892717/18218942448641560}
R3_0 n3 n4 {617733356801479/500000000000000000}
C3_1 n3 n4 {6939906281779079/12354667136029580}
R4_0 n4 n5 {685437851623103/500000000000000000}
C4_1 n4 n5 {880473355830919/685437851623103}
R5_0 n5 n6 {4700210229673941/10000000000000000000}
C5_1 n5 n6 {44682639727487750/4700210229673941}
R6_0 n6 n7 {5560848313798549/50000000000000000000}
C6_1 n6 n7 {566893444246332850/5560848313798549}
R7_0 n7 n8 {9563244313345923/100000000000000000000}
C7_1 n7 n8 {958965059926162800/3187748104448641}
R8_0 n8 n9 {443318180894731/4000000000000000000}
C8_1 n8 n9 {291995822475458920/443318180894731}
R9_0 n9 n10 {20396652467198983/100000000000000000000}
C9_1 n9 n10 {18522911640650383000/20396652467198983}
R10_0 n10 n11 {772056839828539/4000000000000000000}
C10_1 n10 n11 {1880017338542173200/772056839828539}
R11_0 n11 n12 {1577895706608333/2000000000000000000}
C11_1 n11 n12 {2385198168212428400/1577895706608333}
R12_0 n12 n13 {7304992099441737/5000000000000000000}
C12_1 n12 n13 {12797597222688795000/2434997366480579}
R13_0 n13 portn {15090449868958333/2000000000000000000}
C13_1 n13 portn {38967477366030380000/15090449868958333}
.ends NONAGON_POSITIVE_REAL
