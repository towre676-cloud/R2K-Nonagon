* Exact decimal-rational passive realization; s=+i*2*pi*f_hz
.subckt NONAGON_POSITIVE_REAL portp portn
R0_0 portp n1 {6831524586356003/500000000000000000}
L1_0 n1 n2 {9294135502608703/100000000000000000000000}
R2_0 n2 n3 {30852616282323/15625000000000000}
C2_1 n2 n3 {911674363964239/6581891473562240}
R3_0 n3 n4 {62364564070457/62500000000000000}
C3_1 n3 n4 {6939906281779079/9978330251273120}
R4_0 n4 n5 {7923241490450509/5000000000000000000}
C4_1 n4 n5 {8804733558309190/7923241490450509}
R5_0 n5 n6 {16118976665270183/50000000000000000000}
C5_1 n5 n6 {223413198637438750/16118976665270183}
R6_0 n6 n7 {334595813405749/1562500000000000000}
C6_1 n6 n7 {283446722123166425/5353533014491984}
R7_0 n7 n8 {5286490892305049/10000000000000000000000}
C7_1 n7 n8 {41098502568264120000/755212984615007}
R8_0 n8 n9 {2080029335551419/10000000000000000000}
C8_1 n8 n9 {104284222312663900/297147047935917}
R9_0 n9 n10 {5419286908202329/50000000000000000000}
C9_1 n9 n10 {9261455820325191500/5419286908202329}
R10_0 n10 n11 {15195990223610943/50000000000000000000}
C10_1 n10 n11 {7833405577259055000/5065330074536981}
R11_0 n11 n12 {1423627972453053/2500000000000000000}
C11_1 n11 n12 {2981497710265535500/1423627972453053}
R12_0 n12 n13 {1291809243510773/2000000000000000000}
C12_1 n12 n13 {6052253013853056800/1291809243510773}
R13_0 n13 n14 {7015000648530299/1000000000000000000}
C13_1 n13 n14 {19483738683015190000/7015000648530299}
R14_0 n14 portn {10567150634906897/2000000000000000000}
C14_1 n14 portn {98876913236754980000/10567150634906897}
.ends NONAGON_POSITIVE_REAL
