* Exact decimal-rational passive realization; s=+i*2*pi*f_hz
.subckt NONAGON_POSITIVE_REAL portp portn
R0_0 portp n1 {1366251127244137/100000000000000000}
L1_0 n1 n2 {9271981558843239/100000000000000000000000}
R2_0 n2 n3 {404235260381841/200000000000000000}
C2_1 n2 n3 {911674363964239/6737254339697350}
R3_0 n3 n4 {1568894974981639/2000000000000000000}
C3_1 n3 n4 {6939906281779079/7844474874908195}
R4_0 n4 n5 {19162027989783083/10000000000000000000}
C4_1 n4 n5 {17609467116618380/19162027989783083}
R5_0 n5 n6 {70936065554253/200000000000000000}
C5_1 n5 n6 {893652794549755/70936065554253}
R6_0 n6 n7 {8661696088281781/1000000000000000000000}
C6_1 n6 n7 {28768951797784884000/8661696088281781}
R7_0 n7 n8 {6254846333349509/25000000000000000000}
C7_1 n7 n8 {260710555781659750/893549476192787}
R8_0 n8 n9 {301529070303829/6250000000000000000}
C8_1 n8 n9 {2315363955081297875/603058140607658}
R9_0 n9 n10 {3844969720328807/10000000000000000000}
C9_1 n9 n10 {4700043346355433000/3844969720328807}
R10_0 n10 n11 {22799536203362263/50000000000000000000}
C10_1 n10 n11 {59629954205310710000/22799536203362263}
R11_0 n11 n12 {1005571537683121/1250000000000000000}
C11_1 n11 n12 {3782658133658160500/1005571537683121}
R12_0 n12 n13 {963908977376613/200000000000000000}
C12_1 n12 n13 {3896747736603038000/963908977376613}
R13_0 n13 portn {398078949975003/40000000000000000}
C13_1 n13 portn {1977538264735099600/398078949975003}
.ends NONAGON_POSITIVE_REAL
