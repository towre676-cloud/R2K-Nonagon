* Exact decimal-rational passive realization; s=+i*2*pi*f_hz
.subckt NONAGON_POSITIVE_REAL portp portn
R0_0 portp n1 {1704638564622417/125000000000000000}
L1_0 n1 n2 {9307805391604733/100000000000000000000000}
R2_0 n2 n3 {409278451502481/200000000000000000}
C2_1 n2 n3 {911674363964239/6821307525041350}
R3_0 n3 n4 {340671788563323/400000000000000000}
C3_1 n3 n4 {991415183111297/1216684959154725}
R4_0 n4 n5 {17533059655383489/10000000000000000000}
C4_1 n4 n5 {17609467116618380/17533059655383489}
R5_0 n5 n6 {4146885720234083/10000000000000000000}
C5_1 n5 n6 {44682639727487750/4146885720234083}
R6_0 n6 n7 {3873746406749557/50000000000000000000}
C6_1 n6 n7 {1438447589889244200/3873746406749557}
R7_0 n7 n8 {1888412994319551/10000000000000000000}
C7_1 n7 n8 {104284222312663900/269773284902793}
R8_0 n8 n9 {9936507371180907/100000000000000000000}
C8_1 n8 n9 {18522911640650383000/9936507371180907}
R9_0 n9 n10 {99089541481273/312500000000000000}
C9_1 n9 n10 {587505418294429125/396358165925092}
R10_0 n10 n11 {5570764634976727/10000000000000000000}
C10_1 n10 n11 {11925990841062142000/5570764634976727}
R11_0 n11 n12 {6687156094807199/10000000000000000000}
C11_1 n11 n12 {30261265069265284000/6687156094807199}
R12_0 n12 n13 {12838898803851799/2000000000000000000}
C12_1 n12 n13 {38967477366030380000/12838898803851799}
R13_0 n13 portn {3316785971202563/500000000000000000}
C13_1 n13 portn {24719228309188745000/3316785971202563}
.ends NONAGON_POSITIVE_REAL
