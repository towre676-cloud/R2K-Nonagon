* Exact decimal-rational passive realization; s=+i*2*pi*f_hz
.subckt NONAGON_POSITIVE_REAL portp portn
R0_0 portp n1 {6820722537191473/500000000000000000}
L1_0 n1 n2 {184152892561701/2000000000000000000000}
C2_0 n2 n3 {50000000000000000000/16148654300081767}
R3_0 n3 n4 {1696891887338567/1000000000000000000}
C3_1 n3 n4 {2735023091892717/16968918873385670}
R4_0 n4 n5 {3268486650586109/2500000000000000000}
C4_1 n4 n5 {6939906281779079/13073946602344436}
R5_0 n5 n6 {218179279526393/200000000000000000}
C5_1 n5 n6 {1760946711661838/1090896397631965}
R6_0 n6 n7 {4591065858572489/10000000000000000000}
C6_1 n6 n7 {44682639727487750/4591065858572489}
R7_0 n7 n8 {1494115197985637/100000000000000000000}
C7_1 n7 n8 {1133786888492665700/1494115197985637}
R8_0 n8 n9 {5890548903537557/50000000000000000000}
C8_1 n8 n9 {205492512841320600/841506986219651}
R9_0 n9 n10 {934903215526631/12500000000000000000}
C9_1 n9 n10 {70191303479677625/71915631963587}
R10_0 n10 n11 {1550048405732263/10000000000000000000}
C10_1 n10 n11 {1852291164065038300/1550048405732263}
R11_0 n11 n12 {31855920994217237/100000000000000000000}
C11_1 n11 n12 {47000433463554330000/31855920994217237}
R12_0 n12 n13 {41371646291653617/100000000000000000000}
C12_1 n12 n13 {119259908410621420000/41371646291653617}
R13_0 n13 n14 {9635202410811229/10000000000000000000}
C13_1 n13 n14 {30261265069265284000/9635202410811229}
R14_0 n14 portn {394971722028281/500000000000000000}
C14_1 n14 portn {3839279166806638500/394971722028281}
.ends NONAGON_POSITIVE_REAL
