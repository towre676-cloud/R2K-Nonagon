* Exact decimal-rational passive realization; s=+i*2*pi*f_hz
.subckt NONAGON_POSITIVE_REAL portp portn
R0_0 portp n1 {13581011569072349/1000000000000000000}
L1_0 n1 n2 {2317856200890993/25000000000000000000000}
R2_0 n2 n3 {4881020881173721/2500000000000000000}
C2_1 n2 n3 {2735023091892717/19524083524694884}
R3_0 n3 n4 {1028978678229709/1250000000000000000}
C3_1 n3 n4 {6939906281779079/8231829425837672}
R4_0 n4 n5 {17493819344727673/10000000000000000000}
C4_1 n4 n5 {17609467116618380/17493819344727673}
R5_0 n5 n6 {4543652237666953/100000000000000000000}
C5_1 n5 n6 {446826397274877500/4543652237666953}
R6_0 n6 n7 {9759284153719381/50000000000000000000}
C6_1 n6 n7 {1438447589889244200/9759284153719381}
R7_0 n7 n8 {23318977334740013/500000000000000000000}
C7_1 n7 n8 {36499477809432365000/23318977334740013}
R8_0 n8 n9 {15720529046431793/100000000000000000000}
C8_1 n8 n9 {18522911640650383000/15720529046431793}
R9_0 n9 n10 {664296436793789/2000000000000000000}
C9_1 n9 n10 {940008669271086600/664296436793789}
R10_0 n10 n11 {4230078224740669/10000000000000000000}
C10_1 n10 n11 {11925990841062142000/4230078224740669}
R11_0 n11 n12 {2485342125520353/2500000000000000000}
C11_1 n11 n12 {7565316267316321000/2485342125520353}
R12_0 n12 n13 {163543162299733/781250000000000000}
C12_1 n12 n13 {30443341692211234375/327086324599466}
R13_0 n13 portn {977535889124299/50000000000000000}
C13_1 n13 portn {2471922830918874500/977535889124299}
.ends NONAGON_POSITIVE_REAL
