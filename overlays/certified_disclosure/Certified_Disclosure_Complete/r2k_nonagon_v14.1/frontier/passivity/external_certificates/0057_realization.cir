* Exact decimal-rational passive realization; s=+i*2*pi*f_hz
.subckt NONAGON_POSITIVE_REAL portp portn
R0_0 portp n1 {13670946650158541/1000000000000000000}
L1_0 n1 n2 {4654718682327341/50000000000000000000000}
C2_0 n2 n3 {312500000000000000/92736019691167}
R3_0 n3 n4 {9414380229532677/5000000000000000000}
C3_1 n3 n4 {911674363964239/6276253486355118}
R4_0 n4 n5 {10568578387219931/10000000000000000000}
C4_1 n4 n5 {6939906281779079/10568578387219931}
R5_0 n5 n6 {14311898272827913/10000000000000000000}
C5_1 n5 n6 {17609467116618380/14311898272827913}
R6_0 n6 n7 {173050703914981/500000000000000000}
C6_1 n6 n7 {144137547508025/11164561542902}
R7_0 n7 n8 {5197190431867817/50000000000000000000}
C7_1 n7 n8 {566893444246332850/5197190431867817}
R8_0 n8 n9 {8339200313517527/100000000000000000000}
C8_1 n8 n9 {2876895179778488400/8339200313517527}
R9_0 n9 n10 {756972475827613/10000000000000000000}
C9_1 n9 n10 {729989556188647300/756972475827613}
R10_0 n10 n11 {4412405607054787/25000000000000000000}
C10_1 n10 n11 {4630727910162595750/4412405607054787}
R11_0 n11 n12 {26557571124173423/100000000000000000000}
C11_1 n11 n12 {47000433463554330000/26557571124173423}
R12_0 n12 n13 {2852518342639613/5000000000000000000}
C12_1 n12 n13 {5962995420531071000/2852518342639613}
R13_0 n13 n14 {215599396283559/400000000000000000}
C13_1 n13 n14 {1210450602770611360/215599396283559}
R14_0 n14 portn {152980335603999/100000000000000000}
C14_1 n14 portn {85317314817925300/16997815067111}
.ends NONAGON_POSITIVE_REAL
