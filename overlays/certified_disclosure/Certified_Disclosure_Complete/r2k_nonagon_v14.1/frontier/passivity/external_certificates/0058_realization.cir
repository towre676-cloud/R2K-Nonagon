* Exact decimal-rational passive realization; s=+i*2*pi*f_hz
.subckt NONAGON_POSITIVE_REAL portp portn
R0_0 portp n1 {6837466390743719/500000000000000000}
L1_0 n1 n2 {2322037884275721/25000000000000000000000}
C2_0 n2 n3 {6250000000000000000/1980359684216839}
R3_0 n3 n4 {9591913726113109/5000000000000000000}
C3_1 n3 n4 {2735023091892717/19183827452226218}
R4_0 n4 n5 {8453309675388943/10000000000000000000}
C4_1 n4 n5 {6939906281779079/8453309675388943}
R5_0 n5 n6 {4917356353321599/2500000000000000000}
C5_1 n5 n6 {4402366779154595/4917356353321599}
R6_0 n6 n7 {4437035430670777/25000000000000000000}
C6_1 n6 n7 {719223794944622100/4437035430670777}
R7_0 n7 n8 {7830256433243023/100000000000000000000}
C7_1 n7 n8 {561530427837421000/602327417941771}
R8_0 n8 n9 {89526645679231/625000000000000000}
C8_1 n8 n9 {463072791016259575/358106582716924}
R9_0 n9 n10 {164335459885661/500000000000000000}
C9_1 n9 n10 {235002167317771650/164335459885661}
R10_0 n10 n11 {905232005817091/2000000000000000000}
C10_1 n10 n11 {2385198168212428400/905232005817091}
R11_0 n11 n12 {7834185343409909/10000000000000000000}
C11_1 n11 n12 {30261265069265284000/7834185343409909}
R12_0 n12 portn {5462469475299857/5000000000000000000}
C12_1 n12 portn {38392791668066385000/5462469475299857}
.ends NONAGON_POSITIVE_REAL
