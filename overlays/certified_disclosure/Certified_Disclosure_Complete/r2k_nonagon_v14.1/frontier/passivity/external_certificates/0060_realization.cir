* Exact decimal-rational passive realization; s=+i*2*pi*f_hz
.subckt NONAGON_POSITIVE_REAL portp portn
R0_0 portp n1 {13688421612651413/1000000000000000000}
L1_0 n1 n2 {4685961171447517/50000000000000000000000}
C2_0 n2 n3 {781250000000000000/284110008946753}
R3_0 n3 n4 {17874155482205379/10000000000000000000}
C3_1 n3 n4 {911674363964239/5958051827401793}
R4_0 n4 n5 {11166781480812797/10000000000000000000}
C4_1 n4 n5 {991415183111297/1595254497258971}
R5_0 n5 n6 {1148664167599989/1000000000000000000}
C5_1 n5 n6 {1760946711661838/1148664167599989}
R6_0 n6 n7 {1441766543612567/5000000000000000000}
C6_1 n6 n7 {22341319863743875/1441766543612567}
R7_0 n7 n8 {688345802612759/5000000000000000000}
C7_1 n7 n8 {56689344424633285/688345802612759}
R8_0 n8 n9 {8123232873519347/50000000000000000000}
C8_1 n8 n9 {3649947780943236500/8123232873519347}
R9_0 n9 n10 {1704666228544533/25000000000000000000}
C9_1 n9 n10 {4630727910162595750/1704666228544533}
R10_0 n10 n11 {41525905387966523/100000000000000000000}
C10_1 n10 n11 {47000433463554330000/41525905387966523}
R11_0 n11 n12 {741659485274341/3125000000000000000}
C11_1 n11 n12 {3726872137831919375/741659485274341}
R12_0 n12 portn {1646563957003351/1250000000000000000}
C12_1 n12 portn {3782658133658160500/1646563957003351}
.ends NONAGON_POSITIVE_REAL
