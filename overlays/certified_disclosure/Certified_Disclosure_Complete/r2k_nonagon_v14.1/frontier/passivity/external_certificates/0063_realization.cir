* Exact decimal-rational passive realization; s=+i*2*pi*f_hz
.subckt NONAGON_POSITIVE_REAL portp portn
R0_0 portp n1 {681127184870063/50000000000000000}
L1_0 n1 n2 {1177783012117507/12500000000000000000000}
C2_0 n2 n3 {10000000000000000000/2982463504391871}
R3_0 n3 n4 {2055350565978053/1000000000000000000}
C3_1 n3 n4 {2735023091892717/20553505659780530}
R4_0 n4 n5 {3154820028311701/5000000000000000000}
C4_1 n4 n5 {6939906281779079/6309640056623402}
R5_0 n5 n6 {8813283909816969/5000000000000000000}
C5_1 n5 n6 {8804733558309190/8813283909816969}
R6_0 n6 n7 {11506329265300007/100000000000000000000}
C6_1 n6 n7 {2876895179778488400/11506329265300007}
R7_0 n7 n8 {2689367399226687/20000000000000000000}
C7_1 n7 n8 {1459979112377294600/2689367399226687}
R8_0 n8 n9 {823356927171607/10000000000000000000}
C8_1 n8 n9 {1852291164065038300/823356927171607}
R9_0 n9 n10 {9108476421873289/25000000000000000000}
C9_1 n9 n10 {11750108365888582500/9108476421873289}
R10_0 n10 n11 {42990057641307053/100000000000000000000}
C10_1 n10 n11 {119259908410621420000/42990057641307053}
R11_0 n11 n12 {7235263689308643/10000000000000000000}
C11_1 n11 n12 {30261265069265284000/7235263689308643}
R12_0 n12 portn {6326387273352283/5000000000000000000}
C12_1 n12 portn {38392791668066385000/6326387273352283}
.ends NONAGON_POSITIVE_REAL
