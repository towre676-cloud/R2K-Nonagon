* Exact decimal-rational passive realization; s=+i*2*pi*f_hz
.subckt NONAGON_POSITIVE_REAL portp portn
R0_0 portp n1 {849571228767853/62500000000000000}
L1_0 n1 n2 {4664910767593143/50000000000000000000000}
C2_0 n2 n3 {5000000000000000000/1466785531911509}
R3_0 n3 n4 {18220553148351397/10000000000000000000}
C3_1 n3 n4 {2735023091892717/18220553148351397}
R4_0 n4 n5 {13072733128767/12500000000000000}
C4_1 n4 n5 {6939906281779079/10458186503013600}
R5_0 n5 n6 {2909414282679361/2500000000000000000}
C5_1 n5 n6 {4402366779154595/2909414282679361}
R6_0 n6 n7 {2988841506531863/10000000000000000000}
C6_1 n6 n7 {44682639727487750/2988841506531863}
R7_0 n7 n8 {11695714930444629/250000000000000000000}
C7_1 n7 n8 {2834467221231664250/11695714930444629}
R8_0 n8 n9 {1192345861110873/10000000000000000000}
C8_1 n8 n9 {13699500856088040/56778374338613}
R9_0 n9 n10 {594387120867219/12500000000000000000}
C9_1 n9 n10 {912486945235809125/594387120867219}
R10_0 n10 n11 {718574948133277/4000000000000000000}
C10_1 n10 n11 {740916465626015320/718574948133277}
R11_0 n11 n12 {6099835216375459/20000000000000000000}
C11_1 n11 n12 {9400086692710866000/6099835216375459}
R12_0 n12 n13 {5009629453283299/10000000000000000000}
C12_1 n12 n13 {917383910850934000/385356111791023}
R13_0 n13 n14 {25745689545071/40000000000000000}
C13_1 n13 n14 {121045060277061136/25745689545071}
R14_0 n14 portn {3501953682382933/2500000000000000000}
C14_1 n14 portn {19196395834033192500/3501953682382933}
.ends NONAGON_POSITIVE_REAL
