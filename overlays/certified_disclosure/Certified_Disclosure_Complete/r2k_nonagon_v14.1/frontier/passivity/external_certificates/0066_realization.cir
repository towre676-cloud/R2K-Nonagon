* Exact decimal-rational passive realization; s=+i*2*pi*f_hz
.subckt NONAGON_POSITIVE_REAL portp portn
R0_0 portp n1 {13599269349420233/1000000000000000000}
L1_0 n1 n2 {4653492738145533/50000000000000000000000}
C2_0 n2 n3 {12500000000000000000/3727099799822257}
R3_0 n3 n4 {3709012293410851/2000000000000000000}
C3_1 n3 n4 {2735023091892717/18545061467054255}
R4_0 n4 n5 {8454565590704117/10000000000000000000}
C4_1 n4 n5 {6939906281779079/8454565590704117}
R5_0 n5 n6 {16514204161885743/10000000000000000000}
C5_1 n5 n6 {374669513119540/351366045997569}
R6_0 n6 n7 {703687622780143/10000000000000000000}
C6_1 n6 n7 {287689517977848840/703687622780143}
R7_0 n7 n8 {17900790723681631/100000000000000000000}
C7_1 n7 n8 {7299895561886473000/17900790723681631}
R8_0 n8 n9 {7871519299381587/100000000000000000000}
C8_1 n8 n9 {18522911640650383000/7871519299381587}
R9_0 n9 n10 {18089218811836487/50000000000000000000}
C9_1 n9 n10 {23500216731777165000/18089218811836487}
R10_0 n10 n11 {46107426262994547/100000000000000000000}
C10_1 n10 n11 {119259908410621420000/46107426262994547}
R11_0 n11 n12 {7110235804636441/10000000000000000000}
C11_1 n11 n12 {30261265069265284000/7110235804636441}
R12_0 n12 portn {6421418582655329/5000000000000000000}
C12_1 n12 portn {3490253788006035000/583765325695939}
.ends NONAGON_POSITIVE_REAL
