* Exact decimal-rational passive realization; s=+i*2*pi*f_hz
.subckt NONAGON_POSITIVE_REAL portp portn
R0_0 portp n1 {6784433647774853/500000000000000000}
L1_0 n1 n2 {9349676169291357/100000000000000000000000}
C2_0 n2 n3 {2500000000000000000/733830737301523}
R3_0 n3 n4 {9633442604205923/5000000000000000000}
C3_1 n3 n4 {2735023091892717/19266885208411846}
R4_0 n4 n5 {7936586508059319/10000000000000000000}
C4_1 n4 n5 {6939906281779079/7936586508059319}
R5_0 n5 n6 {324281645614039/200000000000000000}
C5_1 n5 n6 {1760946711661838/1621408228070195}
R6_0 n6 n7 {9206040942662583/50000000000000000000}
C6_1 n6 n7 {479482529963081400/3068680314220861}
R7_0 n7 n8 {2039874781573949/40000000000000000000}
C7_1 n7 n8 {2919958224754589200/2039874781573949}
R8_0 n8 n9 {511135615560499/3125000000000000000}
C8_1 n8 n9 {2315363955081297875/2044542462241996}
R9_0 n9 n10 {15913417553944627/50000000000000000000}
C9_1 n9 n10 {23500216731777165000/15913417553944627}
R10_0 n10 n11 {48607059424479043/100000000000000000000}
C10_1 n10 n11 {119259908410621420000/48607059424479043}
R11_0 n11 n12 {265688758057251/400000000000000000}
C11_1 n11 n12 {1210450602770611360/265688758057251}
R12_0 n12 portn {13800146875790147/10000000000000000000}
C12_1 n12 portn {76785583336132770000/13800146875790147}
.ends NONAGON_POSITIVE_REAL
