* Exact decimal-rational passive realization; s=+i*2*pi*f_hz
.subckt NONAGON_POSITIVE_REAL portp portn
R0_0 portp n1 {13607579916838457/1000000000000000000}
L1_0 n1 n2 {9129662109594361/100000000000000000000000}
C2_0 n2 n3 {5000000000000000000/1347292094604117}
R3_0 n3 n4 {18036906592604153/10000000000000000000}
C3_1 n3 n4 {2735023091892717/18036906592604153}
R4_0 n4 n5 {977983401348947/1000000000000000000}
C4_1 n4 n5 {991415183111297/1397119144784210}
R5_0 n5 n6 {2940165100278513/2500000000000000000}
C5_1 n5 n6 {4402366779154595/2940165100278513}
R6_0 n6 n7 {4057716409126817/25000000000000000000}
C6_1 n6 n7 {111706599318719375/4057716409126817}
R7_0 n7 n8 {660655991957791/4000000000000000000}
C7_1 n7 n8 {45351475539706628/660655991957791}
R8_0 n8 n9 {6306628750499/400000000000000000}
C8_1 n8 n9 {8219700513652824/4504734821785}
R9_0 n9 n10 {360917251558011/2500000000000000000}
C9_1 n9 n10 {182497389047161825/360917251558011}
R10_0 n10 n11 {5827114518699801/50000000000000000000}
C10_1 n10 n11 {9261455820325191500/5827114518699801}
R11_0 n11 n12 {3131707260743/10000000000000000}
C11_1 n11 n12 {4700043346355433/3131707260743}
R12_0 n12 n13 {2780901367166389/5000000000000000000}
C12_1 n12 n13 {5962995420531071000/2780901367166389}
R13_0 n13 n14 {5207825509510059/10000000000000000000}
C13_1 n13 n14 {30261265069265284000/5207825509510059}
R14_0 n14 portn {8549876161733479/5000000000000000000}
C14_1 n14 portn {38392791668066385000/8549876161733479}
.ends NONAGON_POSITIVE_REAL
