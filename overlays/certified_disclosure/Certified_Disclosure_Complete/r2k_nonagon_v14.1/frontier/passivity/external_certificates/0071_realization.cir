* Exact decimal-rational passive realization; s=+i*2*pi*f_hz
.subckt NONAGON_POSITIVE_REAL portp portn
R0_0 portp n1 {6776310977221983/500000000000000000}
L1_0 n1 n2 {4588521729693361/50000000000000000000000}
C2_0 n2 n3 {5000000000000000000/1413789353628177}
R3_0 n3 n4 {20326043694839863/10000000000000000000}
C3_1 n3 n4 {2735023091892717/20326043694839863}
R4_0 n4 n5 {2891499646139851/5000000000000000000}
C4_1 n4 n5 {6939906281779079/5782999292279702}
R5_0 n5 n6 {4114745441879587/2500000000000000000}
C5_1 n5 n6 {4402366779154595/4114745441879587}
R6_0 n6 n7 {5670389725689621/50000000000000000000}
C6_1 n6 n7 {479482529963081400/1890129908563207}
R7_0 n7 n8 {13188498339500413/100000000000000000000}
C7_1 n7 n8 {7299895561886473000/13188498339500413}
R8_0 n8 n9 {2533038375437789/25000000000000000000}
C8_1 n8 n9 {4630727910162595750/2533038375437789}
R9_0 n9 n10 {902371599916979/2500000000000000000}
C9_1 n9 n10 {1175010836588858250/902371599916979}
R10_0 n10 n11 {4900147462703113/10000000000000000000}
C10_1 n10 n11 {11925990841062142000/4900147462703113}
R11_0 n11 n12 {632190609087527/1000000000000000000}
C11_1 n11 n12 {3026126506926528400/632190609087527}
R12_0 n12 portn {1476936872967813/1000000000000000000}
C12_1 n12 portn {2559519444537759000/492312290989271}
.ends NONAGON_POSITIVE_REAL
