* Exact decimal-rational passive realization; s=+i*2*pi*f_hz
.subckt NONAGON_POSITIVE_REAL portp portn
R0_0 portp n1 {6857481516797009/500000000000000000}
L1_0 n1 n2 {9276695684514957/100000000000000000000000}
C2_0 n2 n3 {100000000000000000000/28940624310456857}
R3_0 n3 n4 {898800273031907/500000000000000000}
C3_1 n3 n4 {2735023091892717/17976005460638140}
R4_0 n4 n5 {1906747491440083/2000000000000000000}
C4_1 n4 n5 {6939906281779079/9533737457200415}
R5_0 n5 n6 {11568065541570037/10000000000000000000}
C5_1 n5 n6 {17609467116618380/11568065541570037}
R6_0 n6 n7 {13659540390607497/100000000000000000000}
C6_1 n6 n7 {14413754750802500/440630335180887}
R7_0 n7 n8 {2243776309296049/12500000000000000000}
C7_1 n7 n8 {283446722123166425/4487552618592098}
R8_0 n8 n9 {14679757619971177/100000000000000000000}
C8_1 n8 n9 {7299895561886473000/14679757619971177}
R9_0 n9 n10 {11352990046401773/100000000000000000000}
C9_1 n9 n10 {18522911640650383000/11352990046401773}
R10_0 n10 n11 {467367924686313/1250000000000000000}
C10_1 n10 n11 {195835139431476375/155789308228771}
R11_0 n11 n12 {4137890077514213/10000000000000000000}
C11_1 n11 n12 {11925990841062142000/4137890077514213}
R12_0 n12 n13 {332417238349883/400000000000000000}
C12_1 n12 n13 {1210450602770611360/332417238349883}
R13_0 n13 portn {6043198299757359/5000000000000000000}
C13_1 n13 portn {12797597222688795000/2014399433252453}
.ends NONAGON_POSITIVE_REAL
