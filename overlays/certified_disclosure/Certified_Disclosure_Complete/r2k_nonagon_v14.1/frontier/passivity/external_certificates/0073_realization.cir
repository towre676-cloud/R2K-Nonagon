* Exact decimal-rational passive realization; s=+i*2*pi*f_hz
.subckt NONAGON_POSITIVE_REAL portp portn
R0_0 portp n1 {6844086844780861/500000000000000000}
L1_0 n1 n2 {4658143348631409/50000000000000000000000}
C2_0 n2 n3 {10000000000000000000/2697097858505107}
R3_0 n3 n4 {9559877573341231/5000000000000000000}
C3_1 n3 n4 {2735023091892717/19119755146682462}
R4_0 n4 n5 {3963856729171013/5000000000000000000}
C4_1 n4 n5 {6939906281779079/7927713458342026}
R5_0 n5 n6 {2520681771008971/2000000000000000000}
C5_1 n5 n6 {3521893423323676/2520681771008971}
R6_0 n6 n7 {567342428674331/5000000000000000000}
C6_1 n6 n7 {22341319863743875/567342428674331}
R7_0 n7 n8 {305285528183037/2000000000000000000}
C7_1 n7 n8 {22675737769853314/305285528183037}
R8_0 n8 n9 {1433868338674187/50000000000000000000}
C8_1 n8 n9 {1438447589889244200/1433868338674187}
R9_0 n9 n10 {848432801518729/6250000000000000000}
C9_1 n9 n10 {130355277890829875/242409371862494}
R10_0 n10 n11 {5851279463002513/50000000000000000000}
C10_1 n10 n11 {9261455820325191500/5851279463002513}
R11_0 n11 n12 {2163200398886069/6250000000000000000}
C11_1 n11 n12 {2937527091472145625/2163200398886069}
R12_0 n12 n13 {5063431412672389/10000000000000000000}
C12_1 n12 n13 {11925990841062142000/5063431412672389}
R13_0 n13 n14 {6075086733821113/10000000000000000000}
C13_1 n13 n14 {30261265069265284000/6075086733821113}
R14_0 n14 portn {16270331071947131/10000000000000000000}
C14_1 n14 portn {76785583336132770000/16270331071947131}
.ends NONAGON_POSITIVE_REAL
