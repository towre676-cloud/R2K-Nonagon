* Exact decimal-rational passive realization; s=+i*2*pi*f_hz
.subckt NONAGON_POSITIVE_REAL portp portn
R0_0 portp n1 {676453595578343/50000000000000000}
L1_0 n1 n2 {9449946850935947/100000000000000000000000}
C2_0 n2 n3 {5000000000000000000/1779191386569923}
R3_0 n3 n4 {1782389300642537/1000000000000000000}
C3_1 n3 n4 {2735023091892717/17823893006425370}
R4_0 n4 n5 {2450116820161289/2500000000000000000}
C4_1 n4 n5 {6939906281779079/9800467280645156}
R5_0 n5 n6 {11139894747690447/10000000000000000000}
C5_1 n5 n6 {17609467116618380/11139894747690447}
R6_0 n6 n7 {2480306653125133/12500000000000000000}
C6_1 n6 n7 {111706599318719375/4960613306250266}
R7_0 n7 n8 {2771761975700169/20000000000000000000}
C7_1 n7 n8 {226757377698533140/2771761975700169}
R8_0 n8 n9 {206762161097673/1250000000000000000}
C8_1 n8 n9 {182497389047161825/413524322195346}
R9_0 n9 n10 {1233511664247927/25000000000000000000}
C9_1 n9 n10 {4630727910162595750/1233511664247927}
R10_0 n10 n11 {291351468717923/625000000000000000}
C10_1 n10 n11 {587505418294429125/582702937435846}
R11_0 n11 n12 {3540969258945291/20000000000000000000}
C11_1 n11 n12 {23851981682124284000/3540969258945291}
R12_0 n12 portn {13673481102137847/10000000000000000000}
C12_1 n12 portn {30261265069265284000/13673481102137847}
.ends NONAGON_POSITIVE_REAL
