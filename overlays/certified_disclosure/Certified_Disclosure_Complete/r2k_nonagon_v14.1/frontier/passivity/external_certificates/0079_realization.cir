* Exact decimal-rational passive realization; s=+i*2*pi*f_hz
.subckt NONAGON_POSITIVE_REAL portp portn
R0_0 portp n1 {6735484374740321/500000000000000000}
L1_0 n1 n2 {4759750305591591/50000000000000000000000}
C2_0 n2 n3 {100000000000000000000/30010589416089143}
R3_0 n3 n4 {3977862324608619/2000000000000000000}
C3_1 n3 n4 {911674363964239/6629770541014365}
R4_0 n4 n5 {6241016086546351/10000000000000000000}
C4_1 n4 n5 {6939906281779079/6241016086546351}
R5_0 n5 n6 {1569974687270803/1000000000000000000}
C5_1 n5 n6 {1760946711661838/1569974687270803}
R6_0 n6 n7 {12922046774847297/100000000000000000000}
C6_1 n6 n7 {319655019975387600/1435782974983033}
R7_0 n7 n8 {4748408773629339/50000000000000000000}
C7_1 n7 n8 {40109316274101500/52180316193729}
R8_0 n8 n9 {2809560571580551/25000000000000000000}
C8_1 n8 n9 {4630727910162595750/2809560571580551}
R9_0 n9 n10 {36623565955567447/100000000000000000000}
C9_1 n9 n10 {47000433463554330000/36623565955567447}
R10_0 n10 n11 {2072878038855531/5000000000000000000}
C10_1 n10 n11 {5962995420531071000/2072878038855531}
R11_0 n11 n12 {1918660992268687/2500000000000000000}
C11_1 n11 n12 {7565316267316321000/1918660992268687}
R12_0 n12 portn {11601290202432539/10000000000000000000}
C12_1 n12 portn {76785583336132770000/11601290202432539}
.ends NONAGON_POSITIVE_REAL
