* Exact decimal-rational passive realization; s=+i*2*pi*f_hz
.subckt NONAGON_POSITIVE_REAL portp portn
R0_0 portp n1 {6680383281061823/500000000000000000}
L1_0 n1 n2 {4669682450071683/50000000000000000000000}
R2_0 n2 n3 {18255326472194197/10000000000000000000}
C2_1 n2 n3 {2735023091892717/18255326472194197}
R3_0 n3 n4 {5334848179453589/10000000000000000000}
C3_1 n3 n4 {6939906281779079/5334848179453589}
R4_0 n4 n5 {3493790100301729/2500000000000000000}
C4_1 n4 n5 {4402366779154595/3493790100301729}
R5_0 n5 n6 {15793415727881/62500000000000000}
C5_1 n5 n6 {36499477809432365/126347325823048}
R6_0 n6 n7 {28903395076886903/500000000000000000000}
C6_1 n6 n7 {92614558203251915000/28903395076886903}
R7_0 n7 n8 {18663534510714443/50000000000000000000}
C7_1 n7 n8 {23500216731777165000/18663534510714443}
R8_0 n8 n9 {1565532777978587/2500000000000000000}
C8_1 n8 n9 {2981497710265535500/1565532777978587}
R9_0 n9 n10 {1407468182415199/400000000000000000}
C9_1 n9 n10 {3071423333445310800/1407468182415199}
R10_0 n10 portn {13812587230784387/5000000000000000000}
C10_1 n10 portn {97418693415075950000/13812587230784387}
.ends NONAGON_POSITIVE_REAL
