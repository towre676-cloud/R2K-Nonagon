* Exact decimal-rational passive realization; s=+i*2*pi*f_hz
.subckt NONAGON_POSITIVE_REAL portp portn
R0_0 portp n1 {8730970108203/625000000000000}
L1_0 n1 n2 {9524323164265421/100000000000000000000000}
C2_0 n2 n3 {20000000000000000000/3768826370672143}
R3_0 n3 n4 {14299817510351187/10000000000000000000}
C3_1 n3 n4 {911674363964239/4766605836783729}
R4_0 n4 n5 {6339885551103101/5000000000000000000}
C4_1 n4 n5 {6939906281779079/12679771102206202}
R5_0 n5 n6 {7737108778294121/10000000000000000000}
C5_1 n5 n6 {17609467116618380/7737108778294121}
R6_0 n6 n7 {762104203138253/2500000000000000000}
C6_1 n6 n7 {22341319863743875/1524208406276506}
R7_0 n7 n8 {3292434086155139/50000000000000000000}
C7_1 n7 n8 {3649947780943236500/3292434086155139}
R8_0 n8 n9 {23960317969808211/100000000000000000000}
C8_1 n8 n9 {18522911640650383000/23960317969808211}
R9_0 n9 n10 {11322110909754063/50000000000000000000}
C9_1 n9 n10 {2611135192419685000/1258012323306007}
R10_0 n10 n11 {3332812956759953/5000000000000000000}
C10_1 n10 n11 {5962995420531071000/3332812956759953}
R11_0 n11 n12 {10582406375390203/50000000000000000000}
C11_1 n11 n12 {151306325346326420000/10582406375390203}
R12_0 n12 portn {276274292445471/100000000000000000}
C12_1 n12 portn {255951944453775900/92091430815157}
.ends NONAGON_POSITIVE_REAL
