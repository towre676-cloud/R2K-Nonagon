* Exact decimal-rational passive realization; s=+i*2*pi*f_hz
.subckt NONAGON_POSITIVE_REAL portp portn
R0_0 portp n1 {13905612384087293/1000000000000000000}
L1_0 n1 n2 {2399655187721539/25000000000000000000000}
R2_0 n2 n3 {1633080501561617/1000000000000000000}
C2_1 n2 n3 {2735023091892717/16330805015616170}
R3_0 n3 n4 {1979294980261447/2000000000000000000}
C3_1 n3 n4 {6939906281779079/9896474901307235}
R4_0 n4 n5 {350761867323177/312500000000000000}
C4_1 n4 n5 {4402366779154595/2806094938585416}
R5_0 n5 n6 {497856329926963/100000000000000000000}
C5_1 n5 n6 {410985025682641200/71122332846709}
R6_0 n6 n7 {1357777932555953/5000000000000000000}
C6_1 n6 n7 {364994778094323650/1357777932555953}
R7_0 n7 n8 {4599021376744911/10000000000000000000}
C7_1 n7 n8 {522227038483937000/511002375193879}
R8_0 n8 n9 {772050026097881/2000000000000000000}
C8_1 n8 n9 {2385198168212428400/772050026097881}
R9_0 n9 n10 {8295426650363503/10000000000000000000}
C9_1 n9 n10 {30261265069265284000/8295426650363503}
R10_0 n10 n11 {5420157771687207/100000000000000000000}
C10_1 n10 n11 {255951944453775900000/1806719257229069}
R11_0 n11 portn {8270873147708377/1000000000000000000}
C11_1 n11 portn {1025459930685010000/435309113037283}
.ends NONAGON_POSITIVE_REAL
