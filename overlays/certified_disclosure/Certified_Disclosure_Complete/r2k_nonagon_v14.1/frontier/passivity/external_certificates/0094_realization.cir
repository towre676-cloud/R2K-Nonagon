* Exact decimal-rational passive realization; s=+i*2*pi*f_hz
.subckt NONAGON_POSITIVE_REAL portp portn
R0_0 portp n1 {1361965838783923/100000000000000000}
L1_0 n1 n2 {9309125268039317/100000000000000000000000}
R2_0 n2 n3 {8815947764366501/5000000000000000000}
C2_1 n2 n3 {2735023091892717/17631895528733002}
R3_0 n3 n4 {8567610993808439/10000000000000000000}
C3_1 n3 n4 {6939906281779079/8567610993808439}
R4_0 n4 n5 {12539645550707563/10000000000000000000}
C4_1 n4 n5 {17609467116618380/12539645550707563}
R5_0 n5 n6 {11790269194925749/50000000000000000000}
C5_1 n5 n6 {223413198637438750/11790269194925749}
R6_0 n6 n7 {2801134984840419/12500000000000000000}
C6_1 n6 n7 {912486945235809125/2801134984840419}
R7_0 n7 n8 {6965985494947441/100000000000000000000}
C7_1 n7 n8 {18522911640650383000/6965985494947441}
R8_0 n8 n9 {7450978771172751/20000000000000000000}
C8_1 n8 n9 {3133362230903622000/2483659590390917}
R9_0 n9 n10 {1580130697252353/2500000000000000000}
C9_1 n9 n10 {2981497710265535500/1580130697252353}
R10_0 n10 n11 {3523112936880753/1000000000000000000}
C10_1 n10 n11 {2559519444537759000/1174370978960251}
R11_0 n11 portn {2818163142653657/1000000000000000000}
C11_1 n11 portn {19483738683015190000/2818163142653657}
.ends NONAGON_POSITIVE_REAL
