* Exact decimal-rational passive realization; s=+i*2*pi*f_hz
.subckt NONAGON_POSITIVE_REAL portp portn
R0_0 portp n1 {6793692942505437/500000000000000000}
L1_0 n1 n2 {187130879225517/2000000000000000000000}
R2_0 n2 n3 {9192097024056749/5000000000000000000}
C2_1 n2 n3 {2735023091892717/18384194048113498}
R3_0 n3 n4 {7882931905975119/10000000000000000000}
C3_1 n3 n4 {141630740444471/160876161346431}
R4_0 n4 n5 {2429307943451667/2000000000000000000}
C4_1 n4 n5 {3521893423323676/2429307943451667}
R5_0 n5 n6 {29114421673756097/100000000000000000000}
C5_1 n5 n6 {446826397274877500/29114421673756097}
R6_0 n6 n7 {1618412291681793/100000000000000000000}
C6_1 n6 n7 {958965059926162800/539470763893931}
R7_0 n7 n8 {21139166552983153/100000000000000000000}
C7_1 n7 n8 {7299895561886473000/21139166552983153}
R8_0 n8 n9 {554307046632863/6250000000000000000}
C8_1 n8 n9 {2315363955081297875/1108614093265726}
R9_0 n9 n10 {1671904963385563/5000000000000000000}
C9_1 n9 n10 {2350021673177716500/1671904963385563}
R10_0 n10 n11 {678749061424991/1000000000000000000}
C10_1 n10 n11 {1192599084106214200/678749061424991}
R11_0 n11 n12 {8523130476590521/2500000000000000000}
C11_1 n11 n12 {1745126894003017500/774830043326411}
R12_0 n12 portn {1487820103206863/500000000000000000}
C12_1 n12 portn {9741869341507595000/1487820103206863}
.ends NONAGON_POSITIVE_REAL
