* Exact decimal-rational passive realization; s=+i*2*pi*f_hz
.subckt NONAGON_POSITIVE_REAL portp portn
R0_0 portp n1 {6944463493135819/500000000000000000}
L1_0 n1 n2 {9382079806796817/100000000000000000000000}
R2_0 n2 n3 {3975534876913987/2500000000000000000}
C2_1 n2 n3 {2735023091892717/15902139507655948}
R3_0 n3 n4 {2938714390959313/2500000000000000000}
C3_1 n3 n4 {6939906281779079/11754857563837252}
R4_0 n4 n5 {2134067667767147/2000000000000000000}
C4_1 n4 n5 {3521893423323676/2134067667767147}
R5_0 n5 n6 {8755349422459649/25000000000000000000}
C5_1 n5 n6 {111706599318719375/8755349422459649}
R6_0 n6 n7 {10110614811168877/50000000000000000000}
C6_1 n6 n7 {3649947780943236500/10110614811168877}
R7_0 n7 n8 {4295800146647209/50000000000000000000}
C7_1 n7 n8 {9261455820325191500/4295800146647209}
R8_0 n8 n9 {34114111967380227/100000000000000000000}
C8_1 n8 n9 {15666811154518110000/11371370655793409}
R9_0 n9 n10 {157637526899291/250000000000000000}
C9_1 n9 n10 {298149771026553550/157637526899291}
R10_0 n10 n11 {1112869903337413/312500000000000000}
C10_1 n10 n11 {4799098958508298125/2225739806674826}
R11_0 n11 portn {6737568923790671/2500000000000000000}
C11_1 n11 portn {48709346707537975000/6737568923790671}
.ends NONAGON_POSITIVE_REAL
