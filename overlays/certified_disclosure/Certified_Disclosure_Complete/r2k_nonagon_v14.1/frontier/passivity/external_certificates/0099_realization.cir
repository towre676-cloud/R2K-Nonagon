* Exact decimal-rational passive realization; s=+i*2*pi*f_hz
.subckt NONAGON_POSITIVE_REAL portp portn
R0_0 portp n1 {13856401897892051/1000000000000000000}
L1_0 n1 n2 {4711197133601013/50000000000000000000000}
R2_0 n2 n3 {2110632776472569/1250000000000000000}
C2_1 n2 n3 {2735023091892717/16885062211780552}
R3_0 n3 n4 {10381136692754161/10000000000000000000}
C3_1 n3 n4 {6939906281779079/10381136692754161}
R4_0 n4 n5 {5513094303891433/5000000000000000000}
C4_1 n4 n5 {8804733558309190/5513094303891433}
R5_0 n5 n6 {769918498302127/2000000000000000000}
C5_1 n5 n6 {8936527945497550/769918498302127}
R6_0 n6 n7 {220699788447633/156250000000000000000}
C6_1 n6 n7 {1498382906134629375/73566596149211}
R7_0 n7 n8 {5218392573380639/25000000000000000000}
C7_1 n7 n8 {1824973890471618250/5218392573380639}
R8_0 n8 n9 {25233382765429/312500000000000000}
C8_1 n8 n9 {463072791016259575/201867062123432}
R9_0 n9 n10 {1617873604920401/5000000000000000000}
C9_1 n9 n10 {2350021673177716500/1617873604920401}
R10_0 n10 n11 {3346381530554917/5000000000000000000}
C10_1 n10 n11 {5962995420531071000/3346381530554917}
R11_0 n11 n12 {17143425808056347/5000000000000000000}
C11_1 n11 n12 {38392791668066385000/17143425808056347}
R12_0 n12 portn {28950383916753167/10000000000000000000}
C12_1 n12 portn {194837386830151900000/28950383916753167}
.ends NONAGON_POSITIVE_REAL
