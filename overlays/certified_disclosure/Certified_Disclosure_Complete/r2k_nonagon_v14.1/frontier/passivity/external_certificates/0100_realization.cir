* Exact decimal-rational passive realization; s=+i*2*pi*f_hz
.subckt NONAGON_POSITIVE_REAL portp portn
R0_0 portp n1 {13859931396555591/1000000000000000000}
L1_0 n1 n2 {1873149704821989/20000000000000000000000}
R2_0 n2 n3 {7389439328626461/5000000000000000000}
C2_1 n2 n3 {911674363964239/4926292885750974}
R3_0 n3 n4 {351365096020987/250000000000000000}
C3_1 n3 n4 {6939906281779079/14054603840839480}
R4_0 n4 n5 {1080455166858163/1250000000000000000}
C4_1 n4 n5 {4402366779154595/2160910333716326}
R5_0 n5 n6 {46111906032549673/100000000000000000000}
C5_1 n5 n6 {446826397274877500/46111906032549673}
R6_0 n6 n7 {3231910912702133/25000000000000000000}
C6_1 n6 n7 {719223794944622100/3231910912702133}
R7_0 n7 n8 {7533286948096409/100000000000000000000}
C7_1 n7 n8 {7299895561886473000/7533286948096409}
R8_0 n8 n9 {3831728671863729/25000000000000000000}
C8_1 n8 n9 {4630727910162595750/3831728671863729}
R9_0 n9 n10 {1254515914888339/4000000000000000000}
C9_1 n9 n10 {1880017338542173200/1254515914888339}
R10_0 n10 n11 {303129545100059/500000000000000000}
C10_1 n10 n11 {596299542053107100/303129545100059}
R11_0 n11 n12 {715508847138401/200000000000000000}
C11_1 n11 n12 {1535711666722655400/715508847138401}
R12_0 n12 portn {43614814497953/15625000000000000}
C12_1 n12 portn {1217733667688449375/174459257991812}
.ends NONAGON_POSITIVE_REAL
