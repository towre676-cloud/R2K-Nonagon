* Exact decimal-rational passive realization; s=+i*2*pi*f_hz
.subckt NONAGON_POSITIVE_REAL portp portn
R0_0 portp n1 {6910466030153253/500000000000000000}
L1_0 n1 n2 {9411552380177391/100000000000000000000000}
R2_0 n2 n3 {16112462244608947/10000000000000000000}
C2_1 n2 n3 {2735023091892717/16112462244608947}
R3_0 n3 n4 {2446758087861893/2000000000000000000}
C3_1 n3 n4 {6939906281779079/12233790439309465}
R4_0 n4 n5 {9945595755369793/10000000000000000000}
C4_1 n4 n5 {17609467116618380/9945595755369793}
R5_0 n5 n6 {4172414855499649/10000000000000000000}
C5_1 n5 n6 {44682639727487750/4172414855499649}
R6_0 n6 n7 {1322315510015391/10000000000000000000}
C6_1 n6 n7 {95896505992616280/440771836671797}
R7_0 n7 n8 {7080687101067851/100000000000000000000}
C7_1 n7 n8 {7299895561886473000/7080687101067851}
R8_0 n8 n9 {1803331537850349/10000000000000000000}
C8_1 n8 n9 {1852291164065038300/1803331537850349}
R9_0 n9 n10 {23541303968444057/100000000000000000000}
C9_1 n9 n10 {47000433463554330000/23541303968444057}
R10_0 n10 n11 {354300169264089/500000000000000000}
C10_1 n10 n11 {596299542053107100/354300169264089}
R11_0 n11 n12 {13020791776519/4000000000000000}
C11_1 n11 n12 {30714233334453108/13020791776519}
R12_0 n12 portn {835081375351837/250000000000000000}
C12_1 n12 portn {4870934670753797500/835081375351837}
.ends NONAGON_POSITIVE_REAL
