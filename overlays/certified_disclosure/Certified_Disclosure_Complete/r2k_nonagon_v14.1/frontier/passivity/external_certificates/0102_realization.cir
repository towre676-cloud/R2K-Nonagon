* Exact decimal-rational passive realization; s=+i*2*pi*f_hz
.subckt NONAGON_POSITIVE_REAL portp portn
R0_0 portp n1 {1728269561579013/125000000000000000}
L1_0 n1 n2 {4697486720337383/50000000000000000000000}
R2_0 n2 n3 {202109023384537/125000000000000000}
C2_1 n2 n3 {2735023091892717/16168721870762960}
R3_0 n3 n4 {1424909624769847/1250000000000000000}
C3_1 n3 n4 {6939906281779079/11399276998158776}
R4_0 n4 n5 {302922424852449/250000000000000000}
C4_1 n4 n5 {880473355830919/605844849704898}
R5_0 n5 n6 {408304110783171/1250000000000000000}
C5_1 n5 n6 {22341319863743875/1633216443132684}
R6_0 n6 n7 {11128038289442841/50000000000000000000}
C6_1 n6 n7 {280765213918710500/856002945341757}
R7_0 n7 n8 {2473290550541237/50000000000000000000}
C7_1 n7 n8 {9261455820325191500/2473290550541237}
R8_0 n8 n9 {7029603050000071/20000000000000000000}
C8_1 n8 n9 {9400086692710866000/7029603050000071}
R9_0 n9 n10 {6165066730973711/10000000000000000000}
C9_1 n9 n10 {11925990841062142000/6165066730973711}
R10_0 n10 n11 {6905539131806357/2000000000000000000}
C10_1 n10 n11 {15357116667226554000/6905539131806357}
R11_0 n11 portn {3030528635029981/1000000000000000000}
C11_1 n11 portn {19483738683015190000/3030528635029981}
.ends NONAGON_POSITIVE_REAL
