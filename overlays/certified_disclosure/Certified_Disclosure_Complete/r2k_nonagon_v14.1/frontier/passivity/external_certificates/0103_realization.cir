* Exact decimal-rational passive realization; s=+i*2*pi*f_hz
.subckt NONAGON_POSITIVE_REAL portp portn
R0_0 portp n1 {86227325804121/6250000000000000}
L1_0 n1 n2 {2360951397280373/25000000000000000000000}
R2_0 n2 n3 {8448384217756309/5000000000000000000}
C2_1 n2 n3 {2735023091892717/16896768435512618}
R3_0 n3 n4 {54139924952043/50000000000000000}
C3_1 n3 n4 {991415183111297/1546854998629800}
R4_0 n4 n5 {11861384756673883/10000000000000000000}
C4_1 n4 n5 {17609467116618380/11861384756673883}
R5_0 n5 n6 {1771226440278987/5000000000000000000}
C5_1 n5 n6 {22341319863743875/1771226440278987}
R6_0 n6 n7 {17198776864634773/500000000000000000000}
C6_1 n6 n7 {14384475898892442000/17198776864634773}
R7_0 n7 n8 {8976221256538771/50000000000000000000}
C7_1 n7 n8 {3649947780943236500/8976221256538771}
R8_0 n8 n9 {737703726783/8000000000000000}
C8_1 n8 n9 {37045823281300766/18442593169575}
R9_0 n9 n10 {15048481674972413/50000000000000000000}
C9_1 n9 n10 {23500216731777165000/15048481674972413}
R10_0 n10 n11 {210143772253017/312500000000000000}
C10_1 n10 n11 {745374427566383875/420287544506034}
R11_0 n11 n12 {16365485933032887/5000000000000000000}
C11_1 n11 n12 {4265865740896265000/1818387325892543}
R12_0 n12 portn {1668600417027851/500000000000000000}
C12_1 n12 portn {9741869341507595000/1668600417027851}
.ends NONAGON_POSITIVE_REAL
