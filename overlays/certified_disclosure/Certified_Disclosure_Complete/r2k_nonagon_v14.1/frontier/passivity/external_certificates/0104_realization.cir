* Exact decimal-rational passive realization; s=+i*2*pi*f_hz
.subckt NONAGON_POSITIVE_REAL portp portn
R0_0 portp n1 {870767459102203/62500000000000000}
L1_0 n1 n2 {1178396272406313/12500000000000000000000}
R2_0 n2 n3 {28974420865307/20000000000000000}
C2_1 n2 n3 {2735023091892717/14487210432653500}
R3_0 n3 n4 {15053118797679133/10000000000000000000}
C3_1 n3 n4 {6939906281779079/15053118797679133}
R4_0 n4 n5 {4125089577528793/5000000000000000000}
C4_1 n4 n5 {8804733558309190/4125089577528793}
R5_0 n5 n6 {260390289596587/500000000000000000}
C5_1 n5 n6 {4468263972748775/520780579193174}
R6_0 n6 n7 {1749295222912177/12500000000000000000}
C6_1 n6 n7 {359611897472311050/1749295222912177}
R7_0 n7 n8 {8583849289597363/100000000000000000000}
C7_1 n7 n8 {7299895561886473000/8583849289597363}
R8_0 n8 n9 {3376855422115459/20000000000000000000}
C8_1 n8 n9 {3704582328130076600/3376855422115459}
R9_0 n9 n10 {3554247813233683/12500000000000000000}
C9_1 n9 n10 {5875054182944291250/3554247813233683}
R10_0 n10 n11 {630771425225359/1000000000000000000}
C10_1 n10 n11 {1192599084106214200/630771425225359}
R11_0 n11 n12 {6912767103833187/2000000000000000000}
C11_1 n11 n12 {1706346296358506000/768085233759243}
R12_0 n12 portn {30586956658975387/10000000000000000000}
C12_1 n12 portn {194837386830151900000/30586956658975387}
.ends NONAGON_POSITIVE_REAL
