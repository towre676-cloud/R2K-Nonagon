* Exact decimal-rational passive realization; s=+i*2*pi*f_hz
.subckt NONAGON_POSITIVE_REAL portp portn
R0_0 portp n1 {13889147348710863/1000000000000000000}
L1_0 n1 n2 {9462468214877169/100000000000000000000000}
R2_0 n2 n3 {1010592768879827/625000000000000000}
C2_1 n2 n3 {2735023091892717/16169484302077232}
R3_0 n3 n4 {6301485015999357/5000000000000000000}
C3_1 n3 n4 {6939906281779079/12602970031998714}
R4_0 n4 n5 {9991804500923353/10000000000000000000}
C4_1 n4 n5 {17609467116618380/9991804500923353}
R5_0 n5 n6 {4459933946015793/10000000000000000000}
C5_1 n5 n6 {44682639727487750/4459933946015793}
R6_0 n6 n7 {478018068592359/10000000000000000000}
C6_1 n6 n7 {113378688849266570/478018068592359}
R7_0 n7 n8 {416575029082577/5000000000000000000}
C7_1 n7 n8 {143844758988924420/416575029082577}
R8_0 n8 n9 {6432303950173699/50000000000000000000}
C8_1 n8 n9 {280765213918710500/494792611551823}
R9_0 n9 n10 {402977133004667/2500000000000000000}
C9_1 n9 n10 {463072791016259575/402977133004667}
R10_0 n10 n11 {1313919778063713/5000000000000000000}
C10_1 n10 n11 {783340557725905500/437973259354571}
R11_0 n11 n12 {667885725994937/1000000000000000000}
C11_1 n11 n12 {1192599084106214200/667885725994937}
R12_0 n12 n13 {33279455079068877/10000000000000000000}
C12_1 n12 n13 {8531731481792530000/3697717231007653}
R13_0 n13 portn {32744377757663247/10000000000000000000}
C13_1 n13 portn {194837386830151900000/32744377757663247}
.ends NONAGON_POSITIVE_REAL
