* Exact decimal-rational passive realization; s=+i*2*pi*f_hz
.subckt NONAGON_POSITIVE_REAL portp portn
R0_0 portp n1 {6932205291673929/500000000000000000}
L1_0 n1 n2 {9490932358576119/100000000000000000000000}
R2_0 n2 n3 {4206385306011163/2500000000000000000}
C2_1 n2 n3 {2735023091892717/16825541224044652}
R3_0 n3 n4 {287346799122237/250000000000000000}
C3_1 n3 n4 {6939906281779079/11493871964889480}
R4_0 n4 n5 {5468228329066243/5000000000000000000}
C4_1 n4 n5 {8804733558309190/5468228329066243}
R5_0 n5 n6 {130223800351599/250000000000000000}
C5_1 n5 n6 {4468263972748775/520895201406396}
R6_0 n6 n7 {498458430446169/2500000000000000000}
C6_1 n6 n7 {182497389047161825/498458430446169}
R7_0 n7 n8 {10272897688611053/100000000000000000000}
C7_1 n7 n8 {18522911640650383000/10272897688611053}
R8_0 n8 n9 {1474048147920219/5000000000000000000}
C8_1 n8 n9 {261113519241968500/163783127546691}
R9_0 n9 n10 {3340883658979993/5000000000000000000}
C9_1 n9 n10 {5962995420531071000/3340883658979993}
R10_0 n10 n11 {31820991238611907/10000000000000000000}
C10_1 n10 n11 {76785583336132770000/31820991238611907}
R11_0 n11 portn {897734638134533/250000000000000000}
C11_1 n11 portn {4870934670753797500/897734638134533}
.ends NONAGON_POSITIVE_REAL
