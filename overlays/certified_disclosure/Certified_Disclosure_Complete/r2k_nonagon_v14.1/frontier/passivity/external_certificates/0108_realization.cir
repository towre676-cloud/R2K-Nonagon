* Exact decimal-rational passive realization; s=+i*2*pi*f_hz
.subckt NONAGON_POSITIVE_REAL portp portn
R0_0 portp n1 {2727154785694547/200000000000000000}
L1_0 n1 n2 {456351563646737/5000000000000000000000}
R2_0 n2 n3 {18248206278383679/10000000000000000000}
C2_1 n2 n3 {911674363964239/6082735426127893}
R3_0 n3 n4 {2606678855595593/2500000000000000000}
C3_1 n3 n4 {6939906281779079/10426715422382372}
R4_0 n4 n5 {13310160554605383/10000000000000000000}
C4_1 n4 n5 {17609467116618380/13310160554605383}
R5_0 n5 n6 {12917762799333137/50000000000000000000}
C5_1 n5 n6 {223413198637438750/12917762799333137}
R6_0 n6 n7 {2745359789861437/12500000000000000000}
C6_1 n6 n7 {283446722123166425/5490719579722874}
R7_0 n7 n8 {2016567776491171/250000000000000000000}
C7_1 n7 n8 {7192237949446221000/2016567776491171}
R8_0 n8 n9 {1918542895790223/10000000000000000000}
C8_1 n8 n9 {729989556188647300/1918542895790223}
R9_0 n9 n10 {2053243779738483/20000000000000000000}
C9_1 n9 n10 {3704582328130076600/2053243779738483}
R10_0 n10 n11 {3703110520265581/10000000000000000000}
C10_1 n10 n11 {4700043346355433000/3703110520265581}
R11_0 n11 n12 {6066383889695607/10000000000000000000}
C11_1 n11 n12 {11925990841062142000/6066383889695607}
R12_0 n12 n13 {387542480318941/125000000000000000}
C12_1 n12 n13 {959819791701659625/387542480318941}
R13_0 n13 portn {3972273534324129/1000000000000000000}
C13_1 n13 portn {19483738683015190000/3972273534324129}
.ends NONAGON_POSITIVE_REAL
