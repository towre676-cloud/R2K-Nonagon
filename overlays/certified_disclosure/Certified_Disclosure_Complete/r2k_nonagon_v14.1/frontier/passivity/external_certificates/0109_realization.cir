* Exact decimal-rational passive realization; s=+i*2*pi*f_hz
.subckt NONAGON_POSITIVE_REAL portp portn
R0_0 portp n1 {3401210492924607/250000000000000000}
L1_0 n1 n2 {9155441723007759/100000000000000000000000}
R2_0 n2 n3 {19285129609688133/10000000000000000000}
C2_1 n2 n3 {911674363964239/6428376536562711}
R3_0 n3 n4 {114980212209997/125000000000000000}
C3_1 n3 n4 {6939906281779079/9198416976799760}
R4_0 n4 n5 {6930051464789489/5000000000000000000}
C4_1 n4 n5 {8804733558309190/6930051464789489}
R5_0 n5 n6 {13527357413273307/50000000000000000000}
C5_1 n5 n6 {223413198637438750/13527357413273307}
R6_0 n6 n7 {19291012030643899/100000000000000000000}
C6_1 n6 n7 {1133786888492665700/19291012030643899}
R7_0 n7 n8 {2379255695643499/100000000000000000000}
C7_1 n7 n8 {2876895179778488400/2379255695643499}
R8_0 n8 n9 {7891889030699187/50000000000000000000}
C8_1 n8 n9 {3649947780943236500/7891889030699187}
R9_0 n9 n10 {3867468269245303/20000000000000000000}
C9_1 n9 n10 {3704582328130076600/3867468269245303}
R10_0 n10 n11 {2185016589638773/10000000000000000000}
C10_1 n10 n11 {4700043346355433000/2185016589638773}
R11_0 n11 n12 {1914099997769969/2500000000000000000}
C11_1 n11 n12 {2981497710265535500/1914099997769969}
R12_0 n12 n13 {26488006448705443/10000000000000000000}
C12_1 n12 n13 {76785583336132770000/26488006448705443}
R13_0 n13 portn {2367511150232777/500000000000000000}
C13_1 n13 portn {9741869341507595000/2367511150232777}
.ends NONAGON_POSITIVE_REAL
