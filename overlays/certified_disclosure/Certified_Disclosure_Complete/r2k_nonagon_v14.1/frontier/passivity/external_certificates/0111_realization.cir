* Exact decimal-rational passive realization; s=+i*2*pi*f_hz
.subckt NONAGON_POSITIVE_REAL portp portn
R0_0 portp n1 {6786733501467493/500000000000000000}
L1_0 n1 n2 {73258253494461/800000000000000000000}
R2_0 n2 n3 {2068176625057959/2000000000000000000}
C2_1 n2 n3 {7780490169904571/34469610417632650}
R3_0 n3 n4 {5347314397873/4000000000000000}
C3_1 n3 n4 {1051851483517421/3819510284195000}
R4_0 n4 n5 {2827716586490051/12500000000000000000}
C4_1 n4 n5 {22895545062286845/5655433172980102}
R5_0 n5 n6 {6865087651504317/5000000000000000000}
C5_1 n5 n6 {7222295236617134/6865087651504317}
R6_0 n6 n7 {7522860239678411/10000000000000000000}
C6_1 n6 n7 {35933022024884414/7522860239678411}
R7_0 n7 n8 {13428020650479603/100000000000000000000}
C7_1 n7 n8 {790244049168987500/1918288664354229}
R8_0 n8 n9 {115772402357609/1000000000000000000}
C8_1 n8 n9 {87247608029989990/115772402357609}
R9_0 n9 n10 {518866618836589/1562500000000000000}
C9_1 n9 n10 {534879952292441875/518866618836589}
R10_0 n10 n11 {3513254611988031/25000000000000000000}
C10_1 n10 n11 {7096489403700372500/1171084870662677}
R11_0 n11 n12 {7210656797131609/10000000000000000000}
C11_1 n11 n12 {13431331242200164000/7210656797131609}
R12_0 n12 n13 {11364542272440151/10000000000000000000}
C12_1 n12 n13 {83118190528398570000/11364542272440151}
R13_0 n13 portn {1389229181216049/250000000000000000}
C13_1 n13 portn {3277406750398242500/1389229181216049}
.ends NONAGON_POSITIVE_REAL
