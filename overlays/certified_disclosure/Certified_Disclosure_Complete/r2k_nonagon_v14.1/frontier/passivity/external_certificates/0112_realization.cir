* Exact decimal-rational passive realization; s=+i*2*pi*f_hz
.subckt NONAGON_POSITIVE_REAL portp portn
R0_0 portp n1 {13639001691994461/1000000000000000000}
L1_0 n1 n2 {2364072186862137/25000000000000000000000}
R2_0 n2 n3 {358286496641829/200000000000000000}
C2_1 n2 n3 {911674363964239/5971441610697150}
R3_0 n3 n4 {2210219727997247/2000000000000000000}
C3_1 n3 n4 {6939906281779079/11051098639986235}
R4_0 n4 n5 {2290602913524369/2000000000000000000}
C4_1 n4 n5 {3521893423323676/2290602913524369}
R5_0 n5 n6 {30736056113056103/100000000000000000000}
C5_1 n5 n6 {446826397274877500/30736056113056103}
R6_0 n6 n7 {1572195410608343/12500000000000000000}
C6_1 n6 n7 {283446722123166425/3144390821216686}
R7_0 n7 n8 {7909655748188303/100000000000000000000}
C7_1 n7 n8 {2876895179778488400/7909655748188303}
R8_0 n8 n9 {9724871171550013/100000000000000000000}
C8_1 n8 n9 {7299895561886473000/9724871171550013}
R9_0 n9 n10 {9568423489703581/50000000000000000000}
C9_1 n9 n10 {9261455820325191500/9568423489703581}
R10_0 n10 n11 {2612753438897371/10000000000000000000}
C10_1 n10 n11 {4700043346355433000/2612753438897371}
R11_0 n11 n12 {6476582708770237/10000000000000000000}
C11_1 n11 n12 {11925990841062142000/6476582708770237}
R12_0 n12 n13 {421006388915317/125000000000000000}
C12_1 n12 n13 {959819791701659625/421006388915317}
R13_0 n13 portn {32558076497085147/10000000000000000000}
C13_1 n13 portn {194837386830151900000/32558076497085147}
.ends NONAGON_POSITIVE_REAL
