* Exact decimal-rational passive realization; s=+i*2*pi*f_hz
.subckt NONAGON_POSITIVE_REAL portp portn
R0_0 portp n1 {3392522499665747/250000000000000000}
L1_0 n1 n2 {4754699835224609/50000000000000000000000}
R2_0 n2 n3 {1025953019016957/500000000000000000}
C2_1 n2 n3 {911674363964239/6839686793446380}
R3_0 n3 n4 {6526423651742983/10000000000000000000}
C3_1 n3 n4 {6939906281779079/6526423651742983}
R4_0 n4 n5 {397925133124421/250000000000000000}
C4_1 n4 n5 {880473355830919/795850266248842}
R5_0 n5 n6 {5510050981675607/25000000000000000000}
C5_1 n5 n6 {111706599318719375/5510050981675607}
R6_0 n6 n7 {545682758428191/5000000000000000000}
C6_1 n6 n7 {47948252996308140/181894252809397}
R7_0 n7 n8 {10766542664625297/100000000000000000000}
C7_1 n7 n8 {7299895561886473000/10766542664625297}
R8_0 n8 n9 {9083878532479421/50000000000000000000}
C8_1 n8 n9 {9261455820325191500/9083878532479421}
R9_0 n9 n10 {5907426365318791/25000000000000000000}
C9_1 n9 n10 {11750108365888582500/5907426365318791}
R10_0 n10 n11 {7102040540936087/10000000000000000000}
C10_1 n10 n11 {11925990841062142000/7102040540936087}
R11_0 n11 n12 {3065278964039593/1000000000000000000}
C11_1 n11 n12 {7678558333613277000/3065278964039593}
R12_0 n12 portn {1904109382198553/500000000000000000}
C12_1 n12 portn {9741869341507595000/1904109382198553}
.ends NONAGON_POSITIVE_REAL
