* Exact decimal-rational passive realization; s=+i*2*pi*f_hz
.subckt NONAGON_POSITIVE_REAL portp portn
R0_0 portp n1 {2726594008705973/200000000000000000}
L1_0 n1 n2 {2282337765429593/25000000000000000000000}
R2_0 n2 n3 {8640172126485867/5000000000000000000}
C2_1 n2 n3 {911674363964239/5760114750990578}
R3_0 n3 n4 {1447522485837089/1250000000000000000}
C3_1 n3 n4 {6939906281779079/11580179886696712}
R4_0 n4 n5 {2299344205842623/2000000000000000000}
C4_1 n4 n5 {3521893423323676/2299344205842623}
R5_0 n5 n6 {16589856333877937/50000000000000000000}
C5_1 n5 n6 {223413198637438750/16589856333877937}
R6_0 n6 n7 {2570139723817123/25000000000000000000}
C6_1 n6 n7 {6591784235422475/59770691251561}
R7_0 n7 n8 {9483924841253591/100000000000000000000}
C7_1 n7 n8 {2876895179778488400/9483924841253591}
R8_0 n8 n9 {7301572267553011/100000000000000000000}
C8_1 n8 n9 {1042842223126639000/1043081752507573}
R9_0 n9 n10 {5473035888659587/25000000000000000000}
C9_1 n9 n10 {4630727910162595750/5473035888659587}
R10_0 n10 n11 {4049273753417841/20000000000000000000}
C10_1 n10 n11 {3133362230903622000/1349757917805947}
R11_0 n11 n12 {7618383175156909/10000000000000000000}
C11_1 n11 n12 {11925990841062142000/7618383175156909}
R12_0 n12 n13 {2140673687299119/1000000000000000000}
C12_1 n12 n13 {2559519444537759000/713557895766373}
R13_0 n13 portn {5869186018399771/1000000000000000000}
C13_1 n13 portn {19483738683015190000/5869186018399771}
.ends NONAGON_POSITIVE_REAL
