* Exact decimal-rational passive realization; s=+i*2*pi*f_hz
.subckt NONAGON_POSITIVE_REAL portp portn
R0_0 portp n1 {849782229832649/62500000000000000}
L1_0 n1 n2 {4579465822559491/50000000000000000000000}
R2_0 n2 n3 {9310667455775971/5000000000000000000}
C2_1 n2 n3 {2735023091892717/18621334911551942}
R3_0 n3 n4 {1924477577800551/2000000000000000000}
C3_1 n3 n4 {6939906281779079/9622387889002755}
R4_0 n4 n5 {6575018539733157/5000000000000000000}
C4_1 n4 n5 {8804733558309190/6575018539733157}
R5_0 n5 n6 {22616819471145449/100000000000000000000}
C5_1 n5 n6 {446826397274877500/22616819471145449}
R6_0 n6 n7 {3568671639495259/20000000000000000000}
C6_1 n6 n7 {226757377698533140/3568671639495259}
R7_0 n7 n8 {7006062078212449/500000000000000000000}
C7_1 n7 n8 {2054925128413206000/1000866011173207}
R8_0 n8 n9 {16686081054617893/100000000000000000000}
C8_1 n8 n9 {7299895561886473000/16686081054617893}
R9_0 n9 n10 {11433053573992879/100000000000000000000}
C9_1 n9 n10 {18522911640650383000/11433053573992879}
R10_0 n10 n11 {3419919325133959/10000000000000000000}
C10_1 n10 n11 {4700043346355433000/3419919325133959}
R11_0 n11 n12 {1031035050854441/2000000000000000000}
C11_1 n11 n12 {2385198168212428400/1031035050854441}
R12_0 n12 n13 {6024672181740351/10000000000000000000}
C12_1 n12 n13 {30261265069265284000/6024672181740351}
R13_0 n13 n14 {536467822561337/1000000000000000000}
C13_1 n13 n14 {7678558333613277000/536467822561337}
R14_0 n14 portn {795219781018323/100000000000000000}
C14_1 n14 portn {21891841216871000/8935053719307}
.ends NONAGON_POSITIVE_REAL
