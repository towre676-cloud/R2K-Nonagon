* Exact decimal-rational passive realization; s=+i*2*pi*f_hz
.subckt NONAGON_POSITIVE_REAL portp portn
R0_0 portp n1 {54388659673293/4000000000000000}
L1_0 n1 n2 {4574096748939491/50000000000000000000000}
R2_0 n2 n3 {946818565992811/500000000000000000}
C2_1 n2 n3 {2735023091892717/18936371319856220}
R3_0 n3 n4 {2015481817539527/2500000000000000000}
C3_1 n3 n4 {6939906281779079/8061927270158108}
R4_0 n4 n5 {3190255414561681/2000000000000000000}
C4_1 n4 n5 {3521893423323676/3190255414561681}
R5_0 n5 n6 {20740416642188407/100000000000000000000}
C5_1 n5 n6 {446826397274877500/20740416642188407}
R6_0 n6 n7 {1579210620873561/25000000000000000000}
C6_1 n6 n7 {79913754993846900/175467846763729}
R7_0 n7 n8 {8568927074294709/50000000000000000000}
C7_1 n7 n8 {3649947780943236500/8568927074294709}
R8_0 n8 n9 {9129185577994837/100000000000000000000}
C8_1 n8 n9 {18522911640650383000/9129185577994837}
R9_0 n9 n10 {18614089245979067/50000000000000000000}
C9_1 n9 n10 {23500216731777165000/18614089245979067}
R10_0 n10 n11 {47348221971843627/100000000000000000000}
C10_1 n10 n11 {119259908410621420000/47348221971843627}
R11_0 n11 n12 {7110500380399123/10000000000000000000}
C11_1 n11 n12 {30261265069265284000/7110500380399123}
R12_0 n12 n13 {7630519015596173/50000000000000000000}
C12_1 n12 n13 {383927916680663850000/7630519015596173}
R13_0 n13 portn {8537755397301857/1000000000000000000}
C13_1 n13 portn {19483738683015190000/8537755397301857}
.ends NONAGON_POSITIVE_REAL
