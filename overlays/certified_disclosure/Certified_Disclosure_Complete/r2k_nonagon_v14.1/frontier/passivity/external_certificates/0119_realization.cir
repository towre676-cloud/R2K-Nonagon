* Exact decimal-rational passive realization; s=+i*2*pi*f_hz
.subckt NONAGON_POSITIVE_REAL portp portn
R0_0 portp n1 {2713916833614331/200000000000000000}
L1_0 n1 n2 {4588366434814313/50000000000000000000000}
R2_0 n2 n3 {19459558555456659/10000000000000000000}
C2_1 n2 n3 {911674363964239/6486519518485553}
R3_0 n3 n4 {7992469656307049/10000000000000000000}
C3_1 n3 n4 {6939906281779079/7992469656307049}
R4_0 n4 n5 {3005493095610629/2000000000000000000}
C4_1 n4 n5 {3521893423323676/3005493095610629}
R5_0 n5 n6 {26919954423853143/100000000000000000000}
C5_1 n5 n6 {446826397274877500/26919954423853143}
R6_0 n6 n7 {2333799689086833/25000000000000000000}
C6_1 n6 n7 {239741264981540700/777933229695611}
R7_0 n7 n8 {2736897985900941/20000000000000000000}
C7_1 n7 n8 {1459979112377294600/2736897985900941}
R8_0 n8 n9 {6178573343224719/50000000000000000000}
C8_1 n8 n9 {9261455820325191500/6178573343224719}
R9_0 n9 n10 {16650054474089167/50000000000000000000}
C9_1 n9 n10 {23500216731777165000/16650054474089167}
R10_0 n10 n11 {5305347360543493/10000000000000000000}
C10_1 n10 n11 {11925990841062142000/5305347360543493}
R11_0 n11 n12 {753827285149987/1250000000000000000}
C11_1 n11 n12 {3782658133658160500/753827285149987}
R12_0 n12 n13 {8595939712237867/20000000000000000000}
C12_1 n12 n13 {13961015152024140000/781449064748897}
R13_0 n13 portn {510430599165481/62500000000000000}
C13_1 n13 portn {1217733667688449375/510430599165481}
.ends NONAGON_POSITIVE_REAL
