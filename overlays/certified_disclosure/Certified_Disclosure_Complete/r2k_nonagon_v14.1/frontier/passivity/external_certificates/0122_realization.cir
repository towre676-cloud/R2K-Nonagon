* Exact decimal-rational passive realization; s=+i*2*pi*f_hz
.subckt NONAGON_POSITIVE_REAL portp portn
R0_0 portp n1 {13835775191325709/1000000000000000000}
L1_0 n1 n2 {2317448469151011/25000000000000000000000}
R2_0 n2 n3 {3331062124930609/2000000000000000000}
C2_1 n2 n3 {2735023091892717/16655310624653045}
R3_0 n3 n4 {679463597134207/625000000000000000}
C3_1 n3 n4 {6939906281779079/10871417554147312}
R4_0 n4 n5 {619991360349743/500000000000000000}
C4_1 n4 n5 {880473355830919/619991360349743}
R5_0 n5 n6 {39579350663974727/100000000000000000000}
C5_1 n5 n6 {446826397274877500/39579350663974727}
R6_0 n6 n7 {435676044465077/2500000000000000000}
C6_1 n6 n7 {14038260695935525/33513541881929}
R7_0 n7 n8 {7214093539893063/50000000000000000000}
C7_1 n7 n8 {9261455820325191500/7214093539893063}
R8_0 n8 n9 {2742974745313999/10000000000000000000}
C8_1 n8 n9 {4700043346355433000/2742974745313999}
R9_0 n9 n10 {1704182863800441/2500000000000000000}
C9_1 n9 n10 {2981497710265535500/1704182863800441}
R10_0 n10 n11 {2965395247789933/1000000000000000000}
C10_1 n10 n11 {7678558333613277000/2965395247789933}
R11_0 n11 portn {4026106951598499/1000000000000000000}
C11_1 n11 portn {19483738683015190000/4026106951598499}
.ends NONAGON_POSITIVE_REAL
