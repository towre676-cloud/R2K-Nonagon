* Exact decimal-rational passive realization; s=+i*2*pi*f_hz
.subckt NONAGON_POSITIVE_REAL portp portn
R0_0 portp n1 {6884271165146843/500000000000000000}
L1_0 n1 n2 {4635165665224221/50000000000000000000000}
R2_0 n2 n3 {853376925629231/500000000000000000}
C2_1 n2 n3 {2735023091892717/17067538512584620}
R3_0 n3 n4 {1256459375404271/1250000000000000000}
C3_1 n3 n4 {6939906281779079/10051675003234168}
R4_0 n4 n5 {3731790190128183/2500000000000000000}
C4_1 n4 n5 {4402366779154595/3731790190128183}
R5_0 n5 n6 {19460778602243577/100000000000000000000}
C5_1 n5 n6 {446826397274877500/19460778602243577}
R6_0 n6 n7 {4355144411238161/100000000000000000000}
C6_1 n6 n7 {2876895179778488400/4355144411238161}
R7_0 n7 n8 {16093992150159557/100000000000000000000}
C7_1 n7 n8 {7299895561886473000/16093992150159557}
R8_0 n8 n9 {1112578723995037/10000000000000000000}
C8_1 n8 n9 {1852291164065038300/1112578723995037}
R9_0 n9 n10 {1492531131694173/5000000000000000000}
C9_1 n9 n10 {783340557725905500/497510377231391}
R10_0 n10 n11 {667866242613443/1000000000000000000}
C10_1 n10 n11 {1192599084106214200/667866242613443}
R11_0 n11 n12 {14486922986250753/5000000000000000000}
C11_1 n11 n12 {4265865740896265000/1609658109583417}
R12_0 n12 portn {1051530418178107/250000000000000000}
C12_1 n12 portn {4870934670753797500/1051530418178107}
.ends NONAGON_POSITIVE_REAL
