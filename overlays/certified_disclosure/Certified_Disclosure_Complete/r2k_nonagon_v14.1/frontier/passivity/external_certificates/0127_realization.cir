* Exact decimal-rational passive realization; s=+i*2*pi*f_hz
.subckt NONAGON_POSITIVE_REAL portp portn
R0_0 portp n1 {214655609719303/15625000000000000}
L1_0 n1 n2 {1863333851370227/20000000000000000000000}
R2_0 n2 n3 {8813024915687123/5000000000000000000}
C2_1 n2 n3 {2735023091892717/17626049831374246}
R3_0 n3 n4 {10176751668675731/10000000000000000000}
C3_1 n3 n4 {6939906281779079/10176751668675731}
R4_0 n4 n5 {2696976092158433/2000000000000000000}
C4_1 n4 n5 {3521893423323676/2696976092158433}
R5_0 n5 n6 {14590539389525587/50000000000000000000}
C5_1 n5 n6 {223413198637438750/14590539389525587}
R6_0 n6 n7 {3135508182822451/50000000000000000000}
C6_1 n6 n7 {1438447589889244200/3135508182822451}
R7_0 n7 n8 {1448151637254069/10000000000000000000}
C7_1 n7 n8 {729989556188647300/1448151637254069}
R8_0 n8 n9 {12663495617133377/100000000000000000000}
C8_1 n8 n9 {18522911640650383000/12663495617133377}
R9_0 n9 n10 {26412432584416477/100000000000000000000}
C9_1 n9 n10 {47000433463554330000/26412432584416477}
R10_0 n10 n11 {1772856573850539/2500000000000000000}
C10_1 n10 n11 {2981497710265535500/1772856573850539}
R11_0 n11 n12 {2813710319016619/1000000000000000000}
C11_1 n11 n12 {698050757601207000/255791847183329}
R12_0 n12 portn {67461342887911/15625000000000000}
C12_1 n12 portn {1217733667688449375/269845371551644}
.ends NONAGON_POSITIVE_REAL
