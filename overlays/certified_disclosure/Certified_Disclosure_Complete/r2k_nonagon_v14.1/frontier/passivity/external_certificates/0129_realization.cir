* Exact decimal-rational passive realization; s=+i*2*pi*f_hz
.subckt NONAGON_POSITIVE_REAL portp portn
R0_0 portp n1 {2717817688228007/200000000000000000}
L1_0 n1 n2 {4517972054014333/50000000000000000000000}
R2_0 n2 n3 {19299130555179183/10000000000000000000}
C2_1 n2 n3 {911674363964239/6433043518393061}
R3_0 n3 n4 {9069129185662033/10000000000000000000}
C3_1 n3 n4 {6939906281779079/9069129185662033}
R4_0 n4 n5 {850081541848463/625000000000000000}
C4_1 n4 n5 {4402366779154595/3400326167393852}
R5_0 n5 n6 {2487314130103629/10000000000000000000}
C5_1 n5 n6 {44682639727487750/2487314130103629}
R6_0 n6 n7 {765287990827747/4000000000000000000}
C6_1 n6 n7 {1054685477667596/17797395135529}
R7_0 n7 n8 {4433938223195757/1000000000000000000000}
C7_1 n7 n8 {9589650599261628000/1477979407731919}
R8_0 n8 n9 {8517238461142431/50000000000000000000}
C8_1 n8 n9 {3649947780943236500/8517238461142431}
R9_0 n9 n10 {6322819130372659/50000000000000000000}
C9_1 n9 n10 {9261455820325191500/6322819130372659}
R10_0 n10 n11 {1751789091356601/5000000000000000000}
C10_1 n10 n11 {783340557725905500/583929697118867}
R11_0 n11 n12 {44703049282257/100000000000000000}
C11_1 n11 n12 {119259908410621420/44703049282257}
R12_0 n12 n13 {8151075492547413/10000000000000000000}
C12_1 n12 n13 {30261265069265284000/8151075492547413}
R13_0 n13 n14 {2474385091271823/500000000000000000}
C13_1 n13 n14 {9741869341507595000/2474385091271823}
R14_0 n14 portn {9098401530669237/1000000000000000000}
C14_1 n14 portn {49438456618377490000/9098401530669237}
.ends NONAGON_POSITIVE_REAL
