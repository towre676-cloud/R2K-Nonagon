* Exact decimal-rational passive realization; s=+i*2*pi*f_hz
.subckt NONAGON_POSITIVE_REAL portp portn
R0_0 portp n1 {2717787427314957/200000000000000000}
L1_0 n1 n2 {4512257253654743/50000000000000000000000}
R2_0 n2 n3 {1973530558544457/1000000000000000000}
C2_1 n2 n3 {911674363964239/6578435195148190}
R3_0 n3 n4 {7097539563323743/10000000000000000000}
C3_1 n3 n4 {6939906281779079/7097539563323743}
R4_0 n4 n5 {4256391844339467/2500000000000000000}
C4_1 n4 n5 {4402366779154595/4256391844339467}
R5_0 n5 n6 {168456028891223/781250000000000000}
C5_1 n5 n6 {111706599318719375/5390592924519136}
R6_0 n6 n7 {2467510167828459/62500000000000000000}
C6_1 n6 n7 {599353162453851750/822503389276153}
R7_0 n7 n8 {4972598116516317/25000000000000000000}
C7_1 n7 n8 {260710555781659750/710371159502331}
R8_0 n8 n9 {1959209770239/25000000000000000}
C8_1 n8 n9 {18522911640650383/7836839080956}
R9_0 n9 n10 {1600674201531831/4000000000000000000}
C9_1 n9 n10 {626672446180724400/533558067177277}
R10_0 n10 n11 {9202044078790241/25000000000000000000}
C10_1 n10 n11 {29814977102655355000/9202044078790241}
R11_0 n11 n12 {4906024223148631/5000000000000000000}
C11_1 n11 n12 {15130632534632642000/4906024223148631}
R12_0 n12 n13 {2127183287195331/1000000000000000000}
C12_1 n12 n13 {19483738683015190000/2127183287195331}
R13_0 n13 portn {1514099400065137/100000000000000000}
C13_1 n13 portn {4943845661837749000/1514099400065137}
.ends NONAGON_POSITIVE_REAL
