* Exact decimal-rational passive realization; s=+i*2*pi*f_hz
.subckt NONAGON_POSITIVE_REAL portp portn
R0_0 portp n1 {6781012462004271/500000000000000000}
L1_0 n1 n2 {9050059978003731/100000000000000000000000}
R2_0 n2 n3 {4039716818847891/2000000000000000000}
C2_1 n2 n3 {911674363964239/6732861364746485}
R3_0 n3 n4 {3615229648402641/5000000000000000000}
C3_1 n3 n4 {6939906281779079/7230459296805282}
R4_0 n4 n5 {784642099876459/500000000000000000}
C4_1 n4 n5 {880473355830919/784642099876459}
R5_0 n5 n6 {30489824040546887/100000000000000000000}
C5_1 n5 n6 {446826397274877500/30489824040546887}
R6_0 n6 n7 {3508115621079347/50000000000000000000}
C6_1 n6 n7 {1438447589889244200/3508115621079347}
R7_0 n7 n8 {8109706468101323/50000000000000000000}
C7_1 n7 n8 {3649947780943236500/8109706468101323}
R8_0 n8 n9 {11267235718592197/100000000000000000000}
C8_1 n8 n9 {18522911640650383000/11267235718592197}
R9_0 n9 n10 {3638136188701869/10000000000000000000}
C9_1 n9 n10 {1566681115451811000/1212712062900623}
R10_0 n10 n11 {8394876312493607/20000000000000000000}
C10_1 n10 n11 {23851981682124284000/8394876312493607}
R11_0 n11 n12 {2231132767924957/2500000000000000000}
C11_1 n11 n12 {7565316267316321000/2231132767924957}
R12_0 n12 n13 {663321797192701/200000000000000000}
C12_1 n12 n13 {3896747736603038000/663321797192701}
R13_0 n13 portn {31678290341053/2500000000000000}
C13_1 n13 portn {123596141545943725/31678290341053}
.ends NONAGON_POSITIVE_REAL
