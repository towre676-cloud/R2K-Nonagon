* Exact decimal-rational passive realization; s=+i*2*pi*f_hz
.subckt NONAGON_POSITIVE_REAL portp portn
R0_0 portp n1 {2709880079977071/200000000000000000}
L1_0 n1 n2 {2325254351768853/25000000000000000000000}
C2_0 n2 n3 {10000000000000000000/3252922837225959}
R3_0 n3 n4 {4092352087072137/2500000000000000000}
C3_1 n3 n4 {911674363964239/5456469449429516}
R4_0 n4 n5 {627801529574383/500000000000000000}
C4_1 n4 n5 {6939906281779079/12556030591487660}
R5_0 n5 n6 {1189357991881483/1250000000000000000}
C5_1 n5 n6 {4402366779154595/2378715983762966}
R6_0 n6 n7 {3605533755727357/10000000000000000000}
C6_1 n6 n7 {44682639727487750/3605533755727357}
R7_0 n7 n8 {6514699449999917/125000000000000000000}
C7_1 n7 n8 {1417233610615832125/6514699449999917}
R8_0 n8 n9 {2432032000779053/25000000000000000000}
C8_1 n8 n9 {719223794944622100/2432032000779053}
R9_0 n9 n10 {3581426919420819/50000000000000000000}
C9_1 n9 n10 {521421111563319500/511632417060117}
R10_0 n10 n11 {675232835257483/5000000000000000000}
C10_1 n10 n11 {926145582032519150/675232835257483}
R11_0 n11 n12 {724010551501597/2000000000000000000}
C11_1 n11 n12 {940008669271086600/724010551501597}
R12_0 n12 n13 {30606271682980473/100000000000000000000}
C12_1 n12 n13 {119259908410621420000/30606271682980473}
R13_0 n13 n14 {5637373508034693/5000000000000000000}
C13_1 n13 n14 {15130632534632642000/5637373508034693}
R14_0 n14 portn {86089331813237/156250000000000000}
C14_1 n14 portn {4799098958508298125/344357327252948}
.ends NONAGON_POSITIVE_REAL
