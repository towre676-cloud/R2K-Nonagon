* Exact decimal-rational passive realization; s=+i*2*pi*f_hz
.subckt NONAGON_POSITIVE_REAL portp portn
R0_0 portp n1 {675098459502467/50000000000000000}
L1_0 n1 n2 {933910545473133/10000000000000000000000}
C2_0 n2 n3 {1250000000000000000/317967690939443}
R3_0 n3 n4 {228650363420381/125000000000000000}
C3_1 n3 n4 {2735023091892717/18292029073630480}
R4_0 n4 n5 {2408717541320799/2500000000000000000}
C4_1 n4 n5 {6939906281779079/9634870165283196}
R5_0 n5 n6 {11804986951283077/10000000000000000000}
C5_1 n5 n6 {17609467116618380/11804986951283077}
R6_0 n6 n7 {24398703413872077/100000000000000000000}
C6_1 n6 n7 {446826397274877500/24398703413872077}
R7_0 n7 n8 {9832032651416303/100000000000000000000}
C7_1 n7 n8 {1133786888492665700/9832032651416303}
R8_0 n8 n9 {854327409756017/12500000000000000000}
C8_1 n8 n9 {359611897472311050/854327409756017}
R9_0 n9 n10 {492914060163089/6250000000000000000}
C9_1 n9 n10 {912486945235809125/985828120326178}
R10_0 n10 n11 {16403803952040271/100000000000000000000}
C10_1 n10 n11 {18522911640650383000/16403803952040271}
R11_0 n11 n12 {2712736004208399/10000000000000000000}
C11_1 n11 n12 {522227038483937000/301415111578711}
R12_0 n12 n13 {1110897268547653/2000000000000000000}
C12_1 n12 n13 {2385198168212428400/1110897268547653}
R13_0 n13 n14 {2286672488281291/5000000000000000000}
C13_1 n13 n14 {15130632534632642000/2286672488281291}
R14_0 n14 portn {484172819966181/250000000000000000}
C14_1 n14 portn {639879861134439750/161390939988727}
.ends NONAGON_POSITIVE_REAL
