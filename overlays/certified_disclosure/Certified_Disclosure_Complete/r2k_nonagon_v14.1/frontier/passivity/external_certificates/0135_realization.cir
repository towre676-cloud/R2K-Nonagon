* Exact decimal-rational passive realization; s=+i*2*pi*f_hz
.subckt NONAGON_POSITIVE_REAL portp portn
R0_0 portp n1 {842171683711671/62500000000000000}
L1_0 n1 n2 {1871623733756707/20000000000000000000000}
C2_0 n2 n3 {50000000000000000000/12953330083301747}
R3_0 n3 n4 {3853230606098003/2000000000000000000}
C3_1 n3 n4 {2735023091892717/19266153030490015}
R4_0 n4 n5 {7378773039630437/10000000000000000000}
C4_1 n4 n5 {6939906281779079/7378773039630437}
R5_0 n5 n6 {1961093124519719/1250000000000000000}
C5_1 n5 n6 {4402366779154595/3922186249039438}
R6_0 n6 n7 {2060444251824039/50000000000000000000}
C6_1 n6 n7 {223413198637438750/2060444251824039}
R7_0 n7 n8 {8030642289057331/50000000000000000000}
C7_1 n7 n8 {1438447589889244200/8030642289057331}
R8_0 n8 n9 {1289978774910273/25000000000000000000}
C8_1 n8 n9 {260710555781659750/184282682130039}
R9_0 n9 n10 {871783025513033/5000000000000000000}
C9_1 n9 n10 {926145582032519150/871783025513033}
R10_0 n10 n11 {12988600339708457/50000000000000000000}
C10_1 n10 n11 {23500216731777165000/12988600339708457}
R11_0 n11 n12 {560958881904081/1000000000000000000}
C11_1 n11 n12 {1192599084106214200/560958881904081}
R12_0 n12 n13 {47367994293850887/100000000000000000000}
C12_1 n12 n13 {302612650692652840000/47367994293850887}
R13_0 n13 portn {4676027358662391/2500000000000000000}
C13_1 n13 portn {6398798611344397500/1558675786220797}
.ends NONAGON_POSITIVE_REAL
