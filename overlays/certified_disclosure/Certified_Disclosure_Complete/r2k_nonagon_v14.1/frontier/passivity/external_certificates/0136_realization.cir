* Exact decimal-rational passive realization; s=+i*2*pi*f_hz
.subckt NONAGON_POSITIVE_REAL portp portn
R0_0 portp n1 {2738632134963737/200000000000000000}
L1_0 n1 n2 {9282190488545971/100000000000000000000000}
C2_0 n2 n3 {12500000000000000000/3292384735815397}
R3_0 n3 n4 {15461712004151739/10000000000000000000}
C3_1 n3 n4 {911674363964239/5153904001383913}
R4_0 n4 n5 {1371461905959071/1000000000000000000}
C4_1 n4 n5 {6939906281779079/13714619059590710}
R5_0 n5 n6 {4171393678669367/5000000000000000000}
C5_1 n5 n6 {8804733558309190/4171393678669367}
R6_0 n6 n7 {2094506620749783/5000000000000000000}
C6_1 n6 n7 {22341319863743875/2094506620749783}
R7_0 n7 n8 {14253498978725767/1000000000000000000000}
C7_1 n7 n8 {11337868884926657000/14253498978725767}
R8_0 n8 n9 {61522855208307/625000000000000000}
C8_1 n8 n9 {3995687749692345/13671745601846}
R9_0 n9 n10 {1771899285498453/20000000000000000000}
C9_1 n9 n10 {1459979112377294600/1771899285498453}
R10_0 n10 n11 {1585448355390827/10000000000000000000}
C10_1 n10 n11 {1852291164065038300/1585448355390827}
R11_0 n11 n12 {28567089742345897/100000000000000000000}
C11_1 n11 n12 {47000433463554330000/28567089742345897}
R12_0 n12 n13 {5641983618590083/10000000000000000000}
C12_1 n12 n13 {11925990841062142000/5641983618590083}
R13_0 n13 n14 {4976241216254853/10000000000000000000}
C13_1 n13 n14 {30261265069265284000/4976241216254853}
R14_0 n14 portn {2263254017444039/1250000000000000000}
C14_1 n14 portn {9598197917016596250/2263254017444039}
.ends NONAGON_POSITIVE_REAL
