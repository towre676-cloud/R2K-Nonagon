* Exact decimal-rational passive realization; s=+i*2*pi*f_hz
.subckt NONAGON_POSITIVE_REAL portp portn
R0_0 portp n1 {2729679733328191/200000000000000000}
L1_0 n1 n2 {116596116339293/1250000000000000000000}
C2_0 n2 n3 {5000000000000000000/1107356647698937}
R3_0 n3 n4 {8663369926632233/5000000000000000000}
C3_1 n3 n4 {2735023091892717/17326739853264466}
R4_0 n4 n5 {667241714976601/625000000000000000}
C4_1 n4 n5 {6939906281779079/10675867439625616}
R5_0 n5 n6 {11162234278911283/10000000000000000000}
C5_1 n5 n6 {17609467116618380/11162234278911283}
R6_0 n6 n7 {2532050206096987/10000000000000000000}
C6_1 n6 n7 {44682639727487750/2532050206096987}
R7_0 n7 n8 {3299241247260221/50000000000000000000}
C7_1 n7 n8 {566893444246332850/3299241247260221}
R8_0 n8 n9 {9337131844447131/100000000000000000000}
C8_1 n8 n9 {319655019975387600/1037459093827459}
R9_0 n9 n10 {861685506919059/10000000000000000000}
C9_1 n9 n10 {729989556188647300/861685506919059}
R10_0 n10 n11 {769283095753749/5000000000000000000}
C10_1 n10 n11 {926145582032519150/769283095753749}
R11_0 n11 n12 {1528398411540353/5000000000000000000}
C11_1 n11 n12 {2350021673177716500/1528398411540353}
R12_0 n12 n13 {5112198926613661/10000000000000000000}
C12_1 n12 n13 {11925990841062142000/5112198926613661}
R13_0 n13 n14 {7609643777670529/10000000000000000000}
C13_1 n13 n14 {30261265069265284000/7609643777670529}
R14_0 n14 n15 {1194428230171637/2000000000000000000}
C14_1 n14 n15 {15357116667226554000/1194428230171637}
R15_0 n15 portn {1401177271349147/500000000000000000}
C15_1 n15 portn {9741869341507595000/1401177271349147}
.ends NONAGON_POSITIVE_REAL
