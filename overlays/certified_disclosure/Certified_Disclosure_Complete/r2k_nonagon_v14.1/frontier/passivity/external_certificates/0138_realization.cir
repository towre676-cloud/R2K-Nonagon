* Exact decimal-rational passive realization; s=+i*2*pi*f_hz
.subckt NONAGON_POSITIVE_REAL portp portn
R0_0 portp n1 {1365566642819143/100000000000000000}
L1_0 n1 n2 {2324426083738089/25000000000000000000000}
C2_0 n2 n3 {20000000000000000000/5181707352130367}
R3_0 n3 n4 {4376932594460237/2500000000000000000}
C3_1 n3 n4 {2735023091892717/17507730377840948}
R4_0 n4 n5 {9192723136261329/10000000000000000000}
C4_1 n4 n5 {991415183111297/1313246162323047}
R5_0 n5 n6 {305499570706149/200000000000000000}
C5_1 n5 n6 {1760946711661838/1527497853530745}
R6_0 n6 n7 {4524313292179119/50000000000000000000}
C6_1 n6 n7 {53275836662564600/167567158969597}
R7_0 n7 n8 {195896538640217/1250000000000000000}
C7_1 n7 n8 {182497389047161825/391793077280434}
R8_0 n8 n9 {9426932997003787/100000000000000000000}
C8_1 n8 n9 {18522911640650383000/9426932997003787}
R9_0 n9 n10 {627014291518859/2000000000000000000}
C9_1 n9 n10 {940008669271086600/627014291518859}
R10_0 n10 n11 {49246683222251/80000000000000000}
C10_1 n10 n11 {95407926728497136/49246683222251}
R11_0 n11 n12 {183031643404027/500000000000000000}
C11_1 n11 n12 {1513063253463264200/183031643404027}
R12_0 n12 portn {495913715413041/250000000000000000}
C12_1 n12 portn {639879861134439750/165304571804347}
.ends NONAGON_POSITIVE_REAL
