* Exact decimal-rational passive realization; s=+i*2*pi*f_hz
.subckt NONAGON_POSITIVE_REAL portp portn
R0_0 portp n1 {3299573765800231/250000000000000000}
L1_0 n1 n2 {4500929809556031/50000000000000000000000}
C2_0 n2 n3 {20000000000000000000/7320094659160097}
R3_0 n3 n4 {19248873345719033/10000000000000000000}
C3_1 n3 n4 {2735023091892717/19248873345719033}
R4_0 n4 n5 {9093753358144251/10000000000000000000}
C4_1 n4 n5 {6939906281779079/9093753358144251}
R5_0 n5 n6 {3099490107698457/2500000000000000000}
C5_1 n5 n6 {4402366779154595/3099490107698457}
R6_0 n6 n7 {7412872008212173/50000000000000000000}
C6_1 n6 n7 {223413198637438750/7412872008212173}
R7_0 n7 n8 {8305811533728183/50000000000000000000}
C7_1 n7 n8 {566893444246332850/8305811533728183}
R8_0 n8 n9 {7489943180413023/50000000000000000000}
C8_1 n8 n9 {3649947780943236500/7489943180413023}
R9_0 n9 n10 {616925753574287/12500000000000000000}
C9_1 n9 n10 {2315363955081297875/616925753574287}
R10_0 n10 n11 {45551772952895787/100000000000000000000}
C10_1 n10 n11 {15666811154518110000/15183924317631929}
R11_0 n11 n12 {613502591125831/2500000000000000000}
C11_1 n11 n12 {2981497710265535500/613502591125831}
R12_0 n12 portn {403246505355217/312500000000000000}
C12_1 n12 portn {945664533414540125/403246505355217}
.ends NONAGON_POSITIVE_REAL
