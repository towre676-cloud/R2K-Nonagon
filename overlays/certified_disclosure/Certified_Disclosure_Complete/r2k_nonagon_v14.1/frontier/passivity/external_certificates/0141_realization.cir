* Exact decimal-rational passive realization; s=+i*2*pi*f_hz
.subckt NONAGON_POSITIVE_REAL portp portn
R0_0 portp n1 {13164629863177763/1000000000000000000}
L1_0 n1 n2 {1809074408704073/20000000000000000000000}
C2_0 n2 n3 {5000000000000000000/1686064132608521}
R3_0 n3 n4 {10650383077703209/10000000000000000000}
C3_1 n3 n4 {23341470509713713/106503830777032090}
R4_0 n4 n5 {6815670587747883/5000000000000000000}
C4_1 n4 n5 {7362960384621947/27262682350991532}
R5_0 n5 n6 {1594154219693939/1000000000000000000}
C5_1 n5 n6 {7222295236617134/7970771098469695}
R6_0 n6 n7 {9089040782411891/100000000000000000000}
C6_1 n6 n7 {359330220248844140/9089040782411891}
R7_0 n7 n8 {4934992438314817/20000000000000000000}
C7_1 n7 n8 {113349078653321272/4934992438314817}
R8_0 n8 n9 {4420559875035799/500000000000000000000}
C8_1 n8 n9 {11118360931869353500/4420559875035799}
R9_0 n9 n10 {1368183217064829/10000000000000000000}
C9_1 n9 n10 {10627988582266700/41460097486813}
R10_0 n10 n11 {13679963475516277/1000000000000000000000}
C10_1 n10 n11 {87247608029989990000/13679963475516277}
R11_0 n11 n12 {578682909083533/2500000000000000000}
C11_1 n11 n12 {542602821930012000/578682909083533}
R12_0 n12 n13 {4824875287128133/50000000000000000000}
C12_1 n12 n13 {26996070518307925000/4824875287128133}
R13_0 n13 n14 {1073123955618457/2000000000000000000}
C13_1 n13 n14 {1703157456888089400/1073123955618457}
R14_0 n14 n15 {10253348237473277/10000000000000000000}
C14_1 n14 n15 {33412392150805780000/10253348237473277}
R15_0 n15 portn {47376672447714893/100000000000000000000}
C15_1 n15 portn {526989333554317600000/47376672447714893}
.ends NONAGON_POSITIVE_REAL
