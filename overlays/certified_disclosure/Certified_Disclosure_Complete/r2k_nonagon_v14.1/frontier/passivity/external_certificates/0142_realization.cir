* Exact decimal-rational passive realization; s=+i*2*pi*f_hz
.subckt NONAGON_POSITIVE_REAL portp portn
R0_0 portp n1 {2633781049748599/200000000000000000}
L1_0 n1 n2 {2255530019473793/25000000000000000000000}
C2_0 n2 n3 {10000000000000000000/3320446506046351}
R3_0 n3 n4 {70791111029123/62500000000000000}
C3_1 n3 n4 {23341470509713713/113265777646596800}
R4_0 n4 n5 {6125359970130113/5000000000000000000}
C4_1 n4 n5 {7362960384621947/24501439880520452}
R5_0 n5 n6 {17070167455163921/10000000000000000000}
C5_1 n5 n6 {14444590473234268/17070167455163921}
R6_0 n6 n7 {5568626806822099/20000000000000000000}
C6_1 n6 n7 {45564801661596754/5568626806822099}
R7_0 n7 n8 {9412081622333313/500000000000000000000}
C7_1 n7 n8 {531399429113335000/285214594616161}
R8_0 n8 n9 {50232226248493/250000000000000000}
C8_1 n8 n9 {55317083441829125/200928904993972}
R9_0 n9 n10 {33051512553549853/100000000000000000000}
C9_1 n9 n10 {34232316946716280000/33051512553549853}
R10_0 n10 n11 {16194030330362997/50000000000000000000}
C10_1 n10 n11 {14192978807400745000/5398010110120999}
R11_0 n11 n12 {5364517153214637/25000000000000000000}
C11_1 n11 n12 {33578328105500410000/5364517153214637}
R12_0 n12 n13 {2198045643861087/2500000000000000000}
C12_1 n12 n13 {8353098037701445000/2198045643861087}
R13_0 n13 portn {76208646212409/125000000000000000}
C13_1 n13 portn {235515433301000/27246566397}
.ends NONAGON_POSITIVE_REAL
