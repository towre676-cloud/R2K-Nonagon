* Exact decimal-rational passive realization; s=+i*2*pi*f_hz
.subckt NONAGON_POSITIVE_REAL portp portn
R0_0 portp n1 {6781267579220331/500000000000000000}
L1_0 n1 n2 {9342028288786311/100000000000000000000000}
C2_0 n2 n3 {5000000000000000000/1698209148710121}
R3_0 n3 n4 {3637178650457101/2000000000000000000}
C3_1 n3 n4 {2735023091892717/18185893252285505}
R4_0 n4 n5 {561282367212271/625000000000000000}
C4_1 n4 n5 {6939906281779079/8980517875396336}
R5_0 n5 n6 {5486376768365001/5000000000000000000}
C5_1 n5 n6 {8804733558309190/5486376768365001}
R6_0 n6 n7 {4815927253749659/25000000000000000000}
C6_1 n6 n7 {111706599318719375/4815927253749659}
R7_0 n7 n8 {7247741015585317/125000000000000000000}
C7_1 n7 n8 {32958921177112375/168552116641519}
R8_0 n8 n9 {911144419493531/12500000000000000000}
C8_1 n8 n9 {359611897472311050/911144419493531}
R9_0 n9 n10 {57846219771033/625000000000000000}
C9_1 n9 n10 {182497389047161825/231384879084132}
R10_0 n10 n11 {4329087592683377/50000000000000000000}
C10_1 n10 n11 {9261455820325191500/4329087592683377}
R11_0 n11 n12 {1070986046813621/2500000000000000000}
C11_1 n11 n12 {1175010836588858250/1070986046813621}
R12_0 n12 n13 {28532986505403217/100000000000000000000}
C12_1 n12 n13 {119259908410621420000/28532986505403217}
R13_0 n13 n14 {216583649975313/200000000000000000}
C13_1 n13 n14 {605225301385305680/216583649975313}
R14_0 n14 portn {11182651692519839/25000000000000000000}
C14_1 n14 portn {191963958340331925000/11182651692519839}
.ends NONAGON_POSITIVE_REAL
