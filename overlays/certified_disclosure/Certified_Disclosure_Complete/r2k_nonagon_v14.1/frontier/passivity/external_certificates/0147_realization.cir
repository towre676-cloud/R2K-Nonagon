* Exact decimal-rational passive realization; s=+i*2*pi*f_hz
.subckt NONAGON_POSITIVE_REAL portp portn
R0_0 portp n1 {13536711338854467/1000000000000000000}
L1_0 n1 n2 {4679946797172373/50000000000000000000000}
C2_0 n2 n3 {10000000000000000000/3497800120803899}
R3_0 n3 n4 {759566382071867/400000000000000000}
C3_1 n3 n4 {2735023091892717/18989159551796675}
R4_0 n4 n5 {7390990421321099/10000000000000000000}
C4_1 n4 n5 {6939906281779079/7390990421321099}
R5_0 n5 n6 {2816014172105101/2000000000000000000}
C5_1 n5 n6 {3521893423323676/2816014172105101}
R6_0 n6 n7 {8584336500580627/100000000000000000000}
C6_1 n6 n7 {2876895179778488400/8584336500580627}
R7_0 n7 n8 {1470792318598931/10000000000000000000}
C7_1 n7 n8 {729989556188647300/1470792318598931}
R8_0 n8 n9 {773635472945671/20000000000000000000}
C8_1 n8 n9 {3704582328130076600/773635472945671}
R9_0 n9 n10 {48167763903233417/100000000000000000000}
C9_1 n9 n10 {47000433463554330000/48167763903233417}
R10_0 n10 n11 {2058618014718733/10000000000000000000}
C10_1 n10 n11 {917383910850934000/158355231901441}
R11_0 n11 n12 {12335049194549127/10000000000000000000}
C11_1 n11 n12 {30261265069265284000/12335049194549127}
R12_0 n12 portn {198408773371963/1000000000000000000}
C12_1 n12 portn {698050757601207000/18037161215633}
.ends NONAGON_POSITIVE_REAL
