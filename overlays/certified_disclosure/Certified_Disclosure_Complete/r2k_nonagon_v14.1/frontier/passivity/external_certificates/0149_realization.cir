* Exact decimal-rational passive realization; s=+i*2*pi*f_hz
.subckt NONAGON_POSITIVE_REAL portp portn
R0_0 portp n1 {680943871086287/50000000000000000}
L1_0 n1 n2 {4576363748743579/50000000000000000000000}
C2_0 n2 n3 {5000000000000000000/1721147130353591}
R3_0 n3 n4 {9562354004540541/5000000000000000000}
C3_1 n3 n4 {911674363964239/6374902669693694}
R4_0 n4 n5 {497507213246987/625000000000000000}
C4_1 n4 n5 {6939906281779079/7960115411951792}
R5_0 n5 n6 {1560721877769/1250000000000000}
C5_1 n5 n6 {880473355830919/624288751107600}
R6_0 n6 n7 {6484797856955809/100000000000000000000}
C6_1 n6 n7 {446826397274877500/6484797856955809}
R7_0 n7 n8 {2060507647180791/12500000000000000000}
C7_1 n7 n8 {283446722123166425/4121015294361582}
R8_0 n8 n9 {7576574388175371/50000000000000000000}
C8_1 n8 n9 {3649947780943236500/7576574388175371}
R9_0 n9 n10 {4581700037430537/50000000000000000000}
C9_1 n9 n10 {9261455820325191500/4581700037430537}
R10_0 n10 n11 {26703401315781/62500000000000000}
C10_1 n10 n11 {39167027886295275/35604535087708}
R11_0 n11 n12 {15736216374917023/50000000000000000000}
C11_1 n11 n12 {59629954205310710000/15736216374917023}
R12_0 n12 n13 {5299956726070867/5000000000000000000}
C12_1 n12 n13 {15130632534632642000/5299956726070867}
R13_0 n13 portn {4830958013597259/10000000000000000000}
C13_1 n13 portn {25595194445377590000/1610319337865753}
.ends NONAGON_POSITIVE_REAL
