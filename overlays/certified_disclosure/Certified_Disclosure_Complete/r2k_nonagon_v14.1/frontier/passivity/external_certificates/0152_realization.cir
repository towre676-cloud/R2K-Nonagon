* Exact decimal-rational passive realization; s=+i*2*pi*f_hz
.subckt NONAGON_POSITIVE_REAL portp portn
R0_0 portp n1 {13593825129971177/1000000000000000000}
L1_0 n1 n2 {93001154299709/1000000000000000000000}
C2_0 n2 n3 {5000000000000000000/1844530552783593}
R3_0 n3 n4 {3248277683793889/2000000000000000000}
C3_1 n3 n4 {2735023091892717/16241388418969445}
R4_0 n4 n5 {5695121911768581/5000000000000000000}
C4_1 n4 n5 {6939906281779079/11390243823537162}
R5_0 n5 n6 {8498420094161181/10000000000000000000}
C5_1 n5 n6 {17609467116618380/8498420094161181}
R6_0 n6 n7 {6277403265328561/20000000000000000000}
C6_1 n6 n7 {89365279454975500/6277403265328561}
R7_0 n7 n8 {328041724955989/10000000000000000000}
C7_1 n7 n8 {113378688849266570/328041724955989}
R8_0 n8 n9 {2945635651479951/50000000000000000000}
C8_1 n8 n9 {159827509987693800/327292850164439}
R9_0 n9 n10 {5253921400805651/50000000000000000000}
C9_1 n9 n10 {521421111563319500/750560200115093}
R10_0 n10 n11 {722819230425953/5000000000000000000}
C10_1 n10 n11 {926145582032519150/722819230425953}
R11_0 n11 n12 {35236565920893217/100000000000000000000}
C11_1 n11 n12 {47000433463554330000/35236565920893217}
R12_0 n12 n13 {8699862903474989/25000000000000000000}
C12_1 n12 n13 {29814977102655355000/8699862903474989}
R13_0 n13 portn {6099117460145739/5000000000000000000}
C13_1 n13 portn {15130632534632642000/6099117460145739}
.ends NONAGON_POSITIVE_REAL
