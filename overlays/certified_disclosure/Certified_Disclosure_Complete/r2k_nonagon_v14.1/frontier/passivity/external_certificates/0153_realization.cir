* Exact decimal-rational passive realization; s=+i*2*pi*f_hz
.subckt NONAGON_POSITIVE_REAL portp portn
R0_0 portp n1 {2712058333997933/200000000000000000}
L1_0 n1 n2 {1170681183546623/12500000000000000000000}
C2_0 n2 n3 {100000000000000000000/31747638457088113}
R3_0 n3 n4 {8714864284283569/5000000000000000000}
C3_1 n3 n4 {2735023091892717/17429728568567138}
R4_0 n4 n5 {974491280457039/1000000000000000000}
C4_1 n4 n5 {6939906281779079/9744912804570390}
R5_0 n5 n6 {9793258194562787/10000000000000000000}
C5_1 n5 n6 {17609467116618380/9793258194562787}
R6_0 n6 n7 {2616798724050879/10000000000000000000}
C6_1 n6 n7 {44682639727487750/2616798724050879}
R7_0 n7 n8 {1015970960419047/100000000000000000000}
C7_1 n7 n8 {1133786888492665700/1015970960419047}
R8_0 n8 n9 {11351601425780997/100000000000000000000}
C8_1 n8 n9 {958965059926162800/3783867141926999}
R9_0 n9 n10 {29570218727150297/500000000000000000000}
C9_1 n9 n10 {5214211115633195000/4224316961021471}
R10_0 n10 n11 {194575336442107/1250000000000000000}
C10_1 n10 n11 {463072791016259575/389150672884214}
R11_0 n11 n12 {6806311126220573/20000000000000000000}
C11_1 n11 n12 {9400086692710866000/6806311126220573}
R12_0 n12 n13 {1794480918933201/4000000000000000000}
C12_1 n12 n13 {4770396336424856800/1794480918933201}
R13_0 n13 n14 {8131936345800973/10000000000000000000}
C13_1 n13 n14 {30261265069265284000/8131936345800973}
R14_0 n14 portn {474937839153737/500000000000000000}
C14_1 n14 portn {3839279166806638500/474937839153737}
.ends NONAGON_POSITIVE_REAL
