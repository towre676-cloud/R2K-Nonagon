* Exact decimal-rational passive realization; s=+i*2*pi*f_hz
.subckt NONAGON_POSITIVE_REAL portp portn
R0_0 portp n1 {13654638113663879/1000000000000000000}
L1_0 n1 n2 {4589612813289923/50000000000000000000000}
C2_0 n2 n3 {1250000000000000000/352995557133531}
R3_0 n3 n4 {229721448443919/125000000000000000}
C3_1 n3 n4 {911674363964239/6125905291837840}
R4_0 n4 n5 {792890453930127/1000000000000000000}
C4_1 n4 n5 {991415183111297/1132700648471610}
R5_0 n5 n6 {11284394779687403/10000000000000000000}
C5_1 n5 n6 {17609467116618380/11284394779687403}
R6_0 n6 n7 {11176044104659119/100000000000000000000}
C6_1 n6 n7 {446826397274877500/11176044104659119}
R7_0 n7 n8 {4791224774449381/50000000000000000000}
C7_1 n7 n8 {566893444246332850/4791224774449381}
R8_0 n8 n9 {1121979000414513/12500000000000000000}
C8_1 n8 n9 {119870632490770350/373993000138171}
R9_0 n9 n10 {7353287585447911/100000000000000000000}
C9_1 n9 n10 {7299895561886473000/7353287585447911}
R10_0 n10 n11 {14640716122816177/100000000000000000000}
C10_1 n10 n11 {18522911640650383000/14640716122816177}
R11_0 n11 n12 {3240600297163881/10000000000000000000}
C11_1 n11 n12 {1566681115451811000/1080200099054627}
R12_0 n12 n13 {1338943141462887/2500000000000000000}
C12_1 n12 n13 {2981497710265535500/1338943141462887}
R13_0 n13 n14 {6135191445405609/10000000000000000000}
C13_1 n13 n14 {30261265069265284000/6135191445405609}
R14_0 n14 portn {7244837238650707/5000000000000000000}
C14_1 n14 portn {38392791668066385000/7244837238650707}
.ends NONAGON_POSITIVE_REAL
