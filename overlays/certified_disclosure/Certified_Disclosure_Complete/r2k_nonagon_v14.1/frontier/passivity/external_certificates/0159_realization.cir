* Exact decimal-rational passive realization; s=+i*2*pi*f_hz
.subckt NONAGON_POSITIVE_REAL portp portn
R0_0 portp n1 {1703617531908839/125000000000000000}
L1_0 n1 n2 {9194185287230867/100000000000000000000000}
C2_0 n2 n3 {5000000000000000000/1417986087802421}
R3_0 n3 n4 {9645281433064511/5000000000000000000}
C3_1 n3 n4 {2735023091892717/19290562866129022}
R4_0 n4 n5 {1542551587195951/2500000000000000000}
C4_1 n4 n5 {6939906281779079/6170206348783804}
R5_0 n5 n6 {1417185787038593/1000000000000000000}
C5_1 n5 n6 {1760946711661838/1417185787038593}
R6_0 n6 n7 {2237088580878237/25000000000000000000}
C6_1 n6 n7 {239741264981540700/745696193626079}
R7_0 n7 n8 {647645054101439/5000000000000000000}
C7_1 n7 n8 {364994778094323650/647645054101439}
R8_0 n8 n9 {252059157456683/2500000000000000000}
C8_1 n8 n9 {463072791016259575/252059157456683}
R9_0 n9 n10 {1132033414073867/3125000000000000000}
C9_1 n9 n10 {2937527091472145625/2264066828147734}
R10_0 n10 n11 {5078612200417769/10000000000000000000}
C10_1 n10 n11 {917383910850934000/390662476955213}
R11_0 n11 n12 {3148010581980263/5000000000000000000}
C11_1 n11 n12 {15130632534632642000/3148010581980263}
R12_0 n12 portn {7153692277902219/5000000000000000000}
C12_1 n12 portn {4265865740896265000/794854697544691}
.ends NONAGON_POSITIVE_REAL
