* Exact decimal-rational passive realization; s=+i*2*pi*f_hz
.subckt NONAGON_POSITIVE_REAL portp portn
R0_0 portp n1 {34498047635763/2500000000000000}
L1_0 n1 n2 {2325574500053299/25000000000000000000000}
C2_0 n2 n3 {2500000000000000000/755549256884477}
R3_0 n3 n4 {16716517218923967/10000000000000000000}
C3_1 n3 n4 {911674363964239/5572172406307989}
R4_0 n4 n5 {2449962390040779/2500000000000000000}
C4_1 n4 n5 {6939906281779079/9799849560163116}
R5_0 n5 n6 {9535389941050323/10000000000000000000}
C5_1 n5 n6 {17609467116618380/9535389941050323}
R6_0 n6 n7 {10023338779243193/50000000000000000000}
C6_1 n6 n7 {223413198637438750/10023338779243193}
R7_0 n7 n8 {4409257816997431/100000000000000000000}
C7_1 n7 n8 {1133786888492665700/4409257816997431}
R8_0 n8 n9 {7649802966500217/100000000000000000000}
C8_1 n8 n9 {319655019975387600/849978107388913}
R9_0 n9 n10 {4289690200000829/50000000000000000000}
C9_1 n9 n10 {280765213918710500/329976169230833}
R10_0 n10 n11 {12703363635822233/100000000000000000000}
C10_1 n10 n11 {18522911640650383000/12703363635822233}
R11_0 n11 n12 {36699110405805633/100000000000000000000}
C11_1 n11 n12 {15666811154518110000/12233036801935211}
R12_0 n12 n13 {2007885701802927/5000000000000000000}
C12_1 n12 n13 {5962995420531071000/2007885701802927}
R13_0 n13 n14 {331117226162147/400000000000000000}
C13_1 n13 n14 {1210450602770611360/331117226162147}
R14_0 n14 portn {10141904650581787/10000000000000000000}
C14_1 n14 portn {76785583336132770000/10141904650581787}
.ends NONAGON_POSITIVE_REAL
