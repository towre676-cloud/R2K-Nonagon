* Exact decimal-rational passive realization; s=+i*2*pi*f_hz
.subckt NONAGON_POSITIVE_REAL portp portn
R0_0 portp n1 {3450978661920547/250000000000000000}
L1_0 n1 n2 {2317790580886531/25000000000000000000000}
C2_0 n2 n3 {200000000000000000/65684196445331}
R3_0 n3 n4 {17086551561041547/10000000000000000000}
C3_1 n3 n4 {911674363964239/5695517187013849}
R4_0 n4 n5 {974010025381807/1250000000000000000}
C4_1 n4 n5 {6939906281779079/7792080203054456}
R5_0 n5 n6 {271712061028257/200000000000000000}
C5_1 n5 n6 {1760946711661838/1358560305141285}
R6_0 n6 n7 {11644436110764853/50000000000000000000}
C6_1 n6 n7 {3649947780943236500/11644436110764853}
R7_0 n7 n8 {2325536950213859/5000000000000000000}
C7_1 n7 n8 {2350021673177716500/2325536950213859}
R8_0 n8 n9 {5920322366742589/20000000000000000000}
C8_1 n8 n9 {1834767821701868000/455409412826353}
R9_0 n9 n10 {5344802136985897/5000000000000000000}
C9_1 n9 n10 {15130632534632642000/5344802136985897}
R10_0 n10 portn {2541348073002329/5000000000000000000}
C10_1 n10 portn {38392791668066385000/2541348073002329}
.ends NONAGON_POSITIVE_REAL
