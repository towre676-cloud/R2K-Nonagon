* Exact decimal-rational passive realization; s=+i*2*pi*f_hz
.subckt NONAGON_POSITIVE_REAL portp portn
R0_0 portp n1 {13772622582794583/1000000000000000000}
L1_0 n1 n2 {4657539725742453/50000000000000000000000}
C2_0 n2 n3 {500000000000000000/153815905448587}
R3_0 n3 n4 {4430408413796197/2500000000000000000}
C3_1 n3 n4 {2735023091892717/17721633655184788}
R4_0 n4 n5 {39171989188983/50000000000000000}
C4_1 n4 n5 {991415183111297/1119199691113800}
R5_0 n5 n6 {12841899326172799/10000000000000000000}
C5_1 n5 n6 {17609467116618380/12841899326172799}
R6_0 n6 n7 {2373566340198433/25000000000000000000}
C6_1 n6 n7 {719223794944622100/2373566340198433}
R7_0 n7 n8 {12451901399189617/100000000000000000000}
C7_1 n7 n8 {7299895561886473000/12451901399189617}
R8_0 n8 n9 {270166489165167/3125000000000000000}
C8_1 n8 n9 {2315363955081297875/1080665956660668}
R9_0 n9 n10 {2014020960620039/5000000000000000000}
C9_1 n9 n10 {2350021673177716500/2014020960620039}
R10_0 n10 n11 {142229007535509/390625000000000000}
C10_1 n10 n11 {3726872137831919375/1137832060284072}
R11_0 n11 n12 {8955514541920113/10000000000000000000}
C11_1 n11 n12 {30261265069265284000/8955514541920113}
R12_0 n12 portn {1786893604562507/2000000000000000000}
C12_1 n12 portn {15357116667226554000/1786893604562507}
.ends NONAGON_POSITIVE_REAL
