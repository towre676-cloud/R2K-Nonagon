* Exact decimal-rational passive realization; s=+i*2*pi*f_hz
.subckt NONAGON_POSITIVE_REAL portp portn
R0_0 portp n1 {3386232560644107/250000000000000000}
L1_0 n1 n2 {9284089343345883/100000000000000000000000}
C2_0 n2 n3 {156250000000000000/56759781379207}
R3_0 n3 n4 {8466550192991341/5000000000000000000}
C3_1 n3 n4 {2735023091892717/16933100385982682}
R4_0 n4 n5 {8012083543857/7812500000000000}
C4_1 n4 n5 {6939906281779079/10255466936136960}
R5_0 n5 n6 {915932829491397/1000000000000000000}
C5_1 n5 n6 {1760946711661838/915932829491397}
R6_0 n6 n7 {9398554832582031/50000000000000000000}
C6_1 n6 n7 {223413198637438750/9398554832582031}
R7_0 n7 n8 {1286897451104211/12500000000000000000}
C7_1 n7 n8 {283446722123166425/2573794902208422}
R8_0 n8 n9 {746043995724521/50000000000000000000}
C8_1 n8 n9 {1438447589889244200/746043995724521}
R9_0 n9 n10 {2885485035056567/25000000000000000000}
C9_1 n9 n10 {1824973890471618250/2885485035056567}
R10_0 n10 n11 {1242994410644867/10000000000000000000}
C10_1 n10 n11 {1852291164065038300/1242994410644867}
R11_0 n11 n12 {737060800992789/2000000000000000000}
C11_1 n11 n12 {313336223090362200/245686933664263}
R12_0 n12 n13 {127968098430097/400000000000000000}
C12_1 n12 n13 {477039633642485680/127968098430097}
R13_0 n13 portn {12145078070752333/10000000000000000000}
C13_1 n13 portn {30261265069265284000/12145078070752333}
.ends NONAGON_POSITIVE_REAL
