* Exact decimal-rational passive realization; s=+i*2*pi*f_hz
.subckt NONAGON_POSITIVE_REAL portp portn
R0_0 portp n1 {13514767112292117/1000000000000000000}
L1_0 n1 n2 {9323538614342899/100000000000000000000000}
C2_0 n2 n3 {100000000000000000000/34986674886675463}
R3_0 n3 n4 {36699695779169/20000000000000000}
C3_1 n3 n4 {2735023091892717/18349847889584500}
R4_0 n4 n5 {861177365117477/1250000000000000000}
C4_1 n4 n5 {6939906281779079/6889418920939816}
R5_0 n5 n6 {13966095008640883/10000000000000000000}
C5_1 n5 n6 {17609467116618380/13966095008640883}
R6_0 n6 n7 {2219071167984227/10000000000000000000}
C6_1 n6 n7 {729989556188647300/2219071167984227}
R7_0 n7 n8 {16240031375496023/1000000000000000000000}
C7_1 n7 n8 {185229116406503830000/16240031375496023}
R8_0 n8 n9 {22943430758853403/50000000000000000000}
C8_1 n8 n9 {23500216731777165000/22943430758853403}
R9_0 n9 n10 {5211559184735337/20000000000000000000}
C9_1 n9 n10 {23851981682124284000/5211559184735337}
R10_0 n10 n11 {11909420428303861/10000000000000000000}
C10_1 n10 n11 {30261265069265284000/11909420428303861}
R11_0 n11 portn {18274590675499577/100000000000000000000}
C11_1 n11 portn {767855833361327700000/18274590675499577}
.ends NONAGON_POSITIVE_REAL
