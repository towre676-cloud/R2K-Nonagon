* Exact decimal-rational passive realization; s=+i*2*pi*f_hz
.subckt NONAGON_POSITIVE_REAL portp portn
R0_0 portp n1 {6742250867189381/500000000000000000}
L1_0 n1 n2 {37465681306657/400000000000000000000}
C2_0 n2 n3 {100000000000000000000/33273273278564057}
R3_0 n3 n4 {9498973491691593/5000000000000000000}
C3_1 n3 n4 {911674363964239/6332648994461062}
R4_0 n4 n5 {6909180841181047/10000000000000000000}
C4_1 n4 n5 {6939906281779079/6909180841181047}
R5_0 n5 n6 {1326511253425351/1000000000000000000}
C5_1 n5 n6 {1760946711661838/1326511253425351}
R6_0 n6 n7 {8653301208899551/100000000000000000000}
C6_1 n6 n7 {2876895179778488400/8653301208899551}
R7_0 n7 n8 {6091400654413573/50000000000000000000}
C7_1 n7 n8 {3649947780943236500/6091400654413573}
R8_0 n8 n9 {4661708970222767/50000000000000000000}
C8_1 n8 n9 {9261455820325191500/4661708970222767}
R9_0 n9 n10 {101869647398143/250000000000000000}
C9_1 n9 n10 {117501083658885825/101869647398143}
R10_0 n10 n11 {1601175533621493/5000000000000000000}
C10_1 n10 n11 {5962995420531071000/1601175533621493}
R11_0 n11 n12 {5174059743356897/5000000000000000000}
C11_1 n11 n12 {15130632534632642000/5174059743356897}
R12_0 n12 portn {5156838816199701/10000000000000000000}
C12_1 n12 portn {25595194445377590000/1718946272066567}
.ends NONAGON_POSITIVE_REAL
