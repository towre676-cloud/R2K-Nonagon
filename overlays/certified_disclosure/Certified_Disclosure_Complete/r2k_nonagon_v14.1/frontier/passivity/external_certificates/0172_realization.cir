* Exact decimal-rational passive realization; s=+i*2*pi*f_hz
.subckt NONAGON_POSITIVE_REAL portp portn
R0_0 portp n1 {864459340047283/62500000000000000}
L1_0 n1 n2 {9275194622972623/100000000000000000000000}
C2_0 n2 n3 {1250000000000000000/444944618416559}
R3_0 n3 n4 {15350974498311673/10000000000000000000}
C3_1 n3 n4 {2735023091892717/15350974498311673}
R4_0 n4 n5 {55809755097619/50000000000000000}
C4_1 n4 n5 {6939906281779079/11161951019523800}
R5_0 n5 n6 {4064496406765983/5000000000000000000}
C5_1 n5 n6 {8804733558309190/4064496406765983}
R6_0 n6 n7 {10985654647806973/50000000000000000000}
C6_1 n6 n7 {223413198637438750/10985654647806973}
R7_0 n7 n8 {10290257808224777/100000000000000000000}
C7_1 n7 n8 {1133786888492665700/10290257808224777}
R8_0 n8 n9 {3224580435250623/100000000000000000000}
C8_1 n8 n9 {319655019975387600/358286715027847}
R9_0 n9 n10 {880818174664351/10000000000000000000}
C9_1 n9 n10 {104284222312663900/125831167809193}
R10_0 n10 n11 {6002471643441133/50000000000000000000}
C10_1 n10 n11 {9261455820325191500/6002471643441133}
R11_0 n11 n12 {19757438299277617/50000000000000000000}
C11_1 n11 n12 {23500216731777165000/19757438299277617}
R12_0 n12 n13 {28459191035858707/100000000000000000000}
C12_1 n12 n13 {119259908410621420000/28459191035858707}
R13_0 n13 portn {507776877618409/400000000000000000}
C13_1 n13 portn {1210450602770611360/507776877618409}
.ends NONAGON_POSITIVE_REAL
