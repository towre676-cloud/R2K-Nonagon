* Exact decimal-rational passive realization; s=+i*2*pi*f_hz
.subckt NONAGON_POSITIVE_REAL portp portn
R0_0 portp n1 {13798237598479883/1000000000000000000}
L1_0 n1 n2 {9329790202259371/100000000000000000000000}
C2_0 n2 n3 {5000000000000000000/1500323469343911}
R3_0 n3 n4 {16401830891432027/10000000000000000000}
C3_1 n3 n4 {2735023091892717/16401830891432027}
R4_0 n4 n5 {4916596642086749/5000000000000000000}
C4_1 n4 n5 {6939906281779079/9833193284173498}
R5_0 n5 n6 {9010382227316129/10000000000000000000}
C5_1 n5 n6 {17609467116618380/9010382227316129}
R6_0 n6 n7 {2071593375094833/10000000000000000000}
C6_1 n6 n7 {44682639727487750/2071593375094833}
R7_0 n7 n8 {6641871625014897/100000000000000000000}
C7_1 n7 n8 {1133786888492665700/6641871625014897}
R8_0 n8 n9 {705803797697833/12500000000000000000}
C8_1 n8 n9 {359611897472311050/705803797697833}
R9_0 n9 n10 {266424594365939/2500000000000000000}
C9_1 n9 n10 {182497389047161825/266424594365939}
R10_0 n10 n11 {4058414457266843/50000000000000000000}
C10_1 n10 n11 {9261455820325191500/4058414457266843}
R11_0 n11 n12 {782264771307269/2000000000000000000}
C11_1 n11 n12 {940008669271086600/782264771307269}
R12_0 n12 n13 {166813077196647/400000000000000000}
C12_1 n12 n13 {477039633642485680/166813077196647}
R13_0 n13 n14 {1577164468810197/2000000000000000000}
C13_1 n13 n14 {6052253013853056800/1577164468810197}
R14_0 n14 portn {2131351931471587/2000000000000000000}
C14_1 n14 portn {1396101515202414000/193759266497417}
.ends NONAGON_POSITIVE_REAL
