* Exact decimal-rational passive realization; s=+i*2*pi*f_hz
.subckt NONAGON_POSITIVE_REAL portp portn
R0_0 portp n1 {684459955429871/50000000000000000}
L1_0 n1 n2 {2341049902129777/25000000000000000000000}
C2_0 n2 n3 {10000000000000000000/3497514534429583}
R3_0 n3 n4 {1636965935643617/1000000000000000000}
C3_1 n3 n4 {2735023091892717/16369659356436170}
R4_0 n4 n5 {10346194951719773/10000000000000000000}
C4_1 n4 n5 {6939906281779079/10346194951719773}
R5_0 n5 n6 {8200223295954423/10000000000000000000}
C5_1 n5 n6 {88489784505620/41207152240977}
R6_0 n6 n7 {435788533257061/2000000000000000000}
C6_1 n6 n7 {8936527945497550/435788533257061}
R7_0 n7 n8 {6424838858489453/100000000000000000000}
C7_1 n7 n8 {1133786888492665700/6424838858489453}
R8_0 n8 n9 {952384678965271/25000000000000000000}
C8_1 n8 n9 {719223794944622100/952384678965271}
R9_0 n9 n10 {9175143063072647/100000000000000000000}
C9_1 n9 n10 {7299895561886473000/9175143063072647}
R10_0 n10 n11 {3098295140580651/25000000000000000000}
C10_1 n10 n11 {4630727910162595750/3098295140580651}
R11_0 n11 n12 {39641286130871/100000000000000000}
C11_1 n11 n12 {47000433463554330/39641286130871}
R12_0 n12 n13 {3331111405268643/12500000000000000000}
C12_1 n12 n13 {14907488551327677500/3331111405268643}
R13_0 n13 portn {13051279149635933/10000000000000000000}
C13_1 n13 portn {30261265069265284000/13051279149635933}
.ends NONAGON_POSITIVE_REAL
