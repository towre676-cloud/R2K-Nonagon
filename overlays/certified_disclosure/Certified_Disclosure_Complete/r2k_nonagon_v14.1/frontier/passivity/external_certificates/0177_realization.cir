* Exact decimal-rational passive realization; s=+i*2*pi*f_hz
.subckt NONAGON_POSITIVE_REAL portp portn
R0_0 portp n1 {13657174775481923/1000000000000000000}
L1_0 n1 n2 {9420982368238739/100000000000000000000000}
C2_0 n2 n3 {1000000000000000000/289539497304587}
R3_0 n3 n4 {8726323573275221/5000000000000000000}
C3_1 n3 n4 {2735023091892717/17452647146550442}
R4_0 n4 n5 {2185063785913561/2500000000000000000}
C4_1 n4 n5 {991415183111297/1248607877664892}
R5_0 n5 n6 {300077497038271/312500000000000000}
C5_1 n5 n6 {4402366779154595/2400619976306168}
R6_0 n6 n7 {744707256021567/5000000000000000000}
C6_1 n6 n7 {22341319863743875/744707256021567}
R7_0 n7 n8 {312863063588531/5000000000000000000}
C7_1 n7 n8 {56689344424633285/312863063588531}
R8_0 n8 n9 {6405434073827221/100000000000000000000}
C8_1 n8 n9 {2876895179778488400/6405434073827221}
R9_0 n9 n10 {7771427707573403/100000000000000000000}
C9_1 n9 n10 {7299895561886473000/7771427707573403}
R10_0 n10 n11 {12881099858557123/100000000000000000000}
C10_1 n10 n11 {18522911640650383000/12881099858557123}
R11_0 n11 n12 {438778857641421/1250000000000000000}
C11_1 n11 n12 {195835139431476375/146259619213807}
R12_0 n12 n13 {11424975120286449/25000000000000000000}
C12_1 n12 n13 {29814977102655355000/11424975120286449}
R13_0 n13 n14 {365056517914759/500000000000000000}
C13_1 n13 n14 {1513063253463264200/365056517914759}
R14_0 n14 portn {5979425480445587/5000000000000000000}
C14_1 n14 portn {38392791668066385000/5979425480445587}
.ends NONAGON_POSITIVE_REAL
