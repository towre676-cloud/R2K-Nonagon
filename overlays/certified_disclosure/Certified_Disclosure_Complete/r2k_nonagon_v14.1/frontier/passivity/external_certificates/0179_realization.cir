* Exact decimal-rational passive realization; s=+i*2*pi*f_hz
.subckt NONAGON_POSITIVE_REAL portp portn
R0_0 portp n1 {6814314607003413/500000000000000000}
L1_0 n1 n2 {4715798578170759/50000000000000000000000}
C2_0 n2 n3 {25000000000000000000/7336293322353749}
R3_0 n3 n4 {18365175080305633/10000000000000000000}
C3_1 n3 n4 {2735023091892717/18365175080305633}
R4_0 n4 n5 {7162938858241227/10000000000000000000}
C4_1 n4 n5 {6939906281779079/7162938858241227}
R5_0 n5 n6 {6151020416526183/5000000000000000000}
C5_1 n5 n6 {8804733558309190/6151020416526183}
R6_0 n6 n7 {6455579749205833/100000000000000000000}
C6_1 n6 n7 {2876895179778488400/6455579749205833}
R7_0 n7 n8 {2828655643126199/20000000000000000000}
C7_1 n7 n8 {1459979112377294600/2828655643126199}
R8_0 n8 n9 {7416870779571253/100000000000000000000}
C8_1 n8 n9 {18522911640650383000/7416870779571253}
R9_0 n9 n10 {2029227675078051/5000000000000000000}
C9_1 n9 n10 {261113519241968500/225469741675339}
R10_0 n10 n11 {48364534588391/125000000000000000}
C10_1 n10 n11 {149074885513276775/48364534588391}
R11_0 n11 n12 {4177982677213073/5000000000000000000}
C11_1 n11 n12 {15130632534632642000/4177982677213073}
R12_0 n12 portn {423395220438287/400000000000000000}
C12_1 n12 portn {3071423333445310800/423395220438287}
.ends NONAGON_POSITIVE_REAL
