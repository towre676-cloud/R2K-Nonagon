* Exact decimal-rational passive realization; s=+i*2*pi*f_hz
.subckt NONAGON_POSITIVE_REAL portp portn
R0_0 portp n1 {6892480071066693/500000000000000000}
L1_0 n1 n2 {9379732583038809/100000000000000000000000}
C2_0 n2 n3 {2000000000000000000/611007107146817}
R3_0 n3 n4 {1667130275638007/1000000000000000000}
C3_1 n3 n4 {2735023091892717/16671302756380070}
R4_0 n4 n5 {489782861258777/500000000000000000}
C4_1 n4 n5 {6939906281779079/9795657225175540}
R5_0 n5 n6 {1797580198801639/2000000000000000000}
C5_1 n5 n6 {3521893423323676/1797580198801639}
R6_0 n6 n7 {22461789543386427/100000000000000000000}
C6_1 n6 n7 {446826397274877500/22461789543386427}
R7_0 n7 n8 {23546700731318227/1000000000000000000000}
C7_1 n7 n8 {11337868884926657000/23546700731318227}
R8_0 n8 n9 {10093328935330587/100000000000000000000}
C8_1 n8 n9 {958965059926162800/3364442978443529}
R9_0 n9 n10 {6576953702412971/100000000000000000000}
C9_1 n9 n10 {7299895561886473000/6576953702412971}
R10_0 n10 n11 {3512296830501767/25000000000000000000}
C10_1 n10 n11 {4630727910162595750/3512296830501767}
R11_0 n11 n12 {71217715217211/200000000000000000}
C11_1 n11 n12 {10444540769678740/7913079468579}
R12_0 n12 n13 {8397788824930217/20000000000000000000}
C12_1 n12 n13 {23851981682124284000/8397788824930217}
R13_0 n13 n14 {410075942654271/500000000000000000}
C13_1 n13 n14 {1513063253463264200/410075942654271}
R14_0 n14 portn {982861213347743/1000000000000000000}
C14_1 n14 portn {7678558333613277000/982861213347743}
.ends NONAGON_POSITIVE_REAL
