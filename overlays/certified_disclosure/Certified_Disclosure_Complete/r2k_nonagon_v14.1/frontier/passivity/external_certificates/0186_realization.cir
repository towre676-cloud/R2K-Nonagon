* Exact decimal-rational passive realization; s=+i*2*pi*f_hz
.subckt NONAGON_POSITIVE_REAL portp portn
R0_0 portp n1 {6898695359555039/500000000000000000}
L1_0 n1 n2 {9431613572560643/100000000000000000000000}
C2_0 n2 n3 {12500000000000000000/4002848817485347}
R3_0 n3 n4 {16466738412304993/10000000000000000000}
C3_1 n3 n4 {2735023091892717/16466738412304993}
R4_0 n4 n5 {8865277624331597/10000000000000000000}
C4_1 n4 n5 {991415183111297/1266468232047371}
R5_0 n5 n6 {3055729983978427/2500000000000000000}
C5_1 n5 n6 {4402366779154595/3055729983978427}
R6_0 n6 n7 {983872400137389/250000000000000000000}
C6_1 n6 n7 {38054169044689000/5205674074801}
R7_0 n7 n8 {22731028798468023/100000000000000000000}
C7_1 n7 n8 {7299895561886473000/22731028798468023}
R8_0 n8 n9 {1122326639650689/100000000000000000000}
C8_1 n8 n9 {18522911640650383000/1122326639650689}
R9_0 n9 n10 {23334887814845863/50000000000000000000}
C9_1 n9 n10 {23500216731777165000/23334887814845863}
R10_0 n10 n11 {7174171652401001/25000000000000000000}
C10_1 n10 n11 {29814977102655355000/7174171652401001}
R11_0 n11 n12 {528781812680687/500000000000000000}
C11_1 n11 n12 {1513063253463264200/528781812680687}
R12_0 n12 portn {1184294676175873/2000000000000000000}
C12_1 n12 portn {15357116667226554000/1184294676175873}
.ends NONAGON_POSITIVE_REAL
