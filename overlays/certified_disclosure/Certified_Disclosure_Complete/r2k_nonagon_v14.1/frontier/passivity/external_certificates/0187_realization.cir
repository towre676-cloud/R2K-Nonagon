* Exact decimal-rational passive realization; s=+i*2*pi*f_hz
.subckt NONAGON_POSITIVE_REAL portp portn
R0_0 portp n1 {1376381703006021/100000000000000000}
L1_0 n1 n2 {4739231477371261/50000000000000000000000}
C2_0 n2 n3 {5000000000000000/1480035841699}
R3_0 n3 n4 {17329074238177603/10000000000000000000}
C3_1 n3 n4 {2735023091892717/17329074238177603}
R4_0 n4 n5 {3993933802094879/5000000000000000000}
C4_1 n4 n5 {6939906281779079/7987867604189758}
R5_0 n5 n6 {1533360503791639/1250000000000000000}
C5_1 n5 n6 {4402366779154595/3066721007583278}
R6_0 n6 n7 {4888921928367237/50000000000000000000}
C6_1 n6 n7 {479482529963081400/1629640642789079}
R7_0 n7 n8 {5482229958697173/50000000000000000000}
C7_1 n7 n8 {3649947780943236500/5482229958697173}
R8_0 n8 n9 {2715898778313893/25000000000000000000}
C8_1 n8 n9 {4630727910162595750/2715898778313893}
R9_0 n9 n10 {3824797867233849/10000000000000000000}
C9_1 n9 n10 {522227038483937000/424977540803761}
R10_0 n10 n11 {3973448397306661/10000000000000000000}
C10_1 n10 n11 {917383910850934000/305649876715897}
R11_0 n11 n12 {8088157066655313/10000000000000000000}
C11_1 n11 n12 {30261265069265284000/8088157066655313}
R12_0 n12 portn {2708191239286083/2500000000000000000}
C12_1 n12 portn {6398798611344397500/902730413095361}
.ends NONAGON_POSITIVE_REAL
