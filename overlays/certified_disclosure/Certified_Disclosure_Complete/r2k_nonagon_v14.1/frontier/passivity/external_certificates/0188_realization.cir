* Exact decimal-rational passive realization; s=+i*2*pi*f_hz
.subckt NONAGON_POSITIVE_REAL portp portn
R0_0 portp n1 {3456177580935351/250000000000000000}
L1_0 n1 n2 {295529739972647/3125000000000000000000}
C2_0 n2 n3 {2500000000000000000/800644100943091}
R3_0 n3 n4 {3543528471374129/2500000000000000000}
C3_1 n3 n4 {2735023091892717/14174113885496516}
R4_0 n4 n5 {12840392730525721/10000000000000000000}
C4_1 n4 n5 {6939906281779079/12840392730525721}
R5_0 n5 n6 {3190357716432379/5000000000000000000}
C5_1 n5 n6 {8804733558309190/3190357716432379}
R6_0 n6 n7 {32428208690500843/100000000000000000000}
C6_1 n6 n7 {446826397274877500/32428208690500843}
R7_0 n7 n8 {7639220390878147/100000000000000000000}
C7_1 n7 n8 {2876895179778488400/7639220390878147}
R8_0 n8 n9 {445528369501271/4000000000000000000}
C8_1 n8 n9 {41713688925065560/63646909928753}
R9_0 n9 n10 {4421671173102617/50000000000000000000}
C9_1 n9 n10 {9261455820325191500/4421671173102617}
R10_0 n10 n11 {8596199868936607/20000000000000000000}
C10_1 n10 n11 {9400086692710866000/8596199868936607}
R11_0 n11 n12 {2897255787519839/10000000000000000000}
C11_1 n11 n12 {11925990841062142000/2897255787519839}
R12_0 n12 n13 {1110819922566507/1000000000000000000}
C12_1 n12 n13 {3026126506926528400/1110819922566507}
R13_0 n13 portn {533536241363171/1000000000000000000}
C13_1 n13 portn {7678558333613277000/533536241363171}
.ends NONAGON_POSITIVE_REAL
