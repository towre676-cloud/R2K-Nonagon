* Exact decimal-rational passive realization; s=+i*2*pi*f_hz
.subckt NONAGON_POSITIVE_REAL portp portn
R0_0 portp n1 {689260436922719/50000000000000000}
L1_0 n1 n2 {4755003619806727/50000000000000000000000}
C2_0 n2 n3 {32000000000000000/9281880263377}
R3_0 n3 n4 {1558910121851031/1000000000000000000}
C3_1 n3 n4 {911674363964239/5196367072836770}
R4_0 n4 n5 {2155191350343207/2000000000000000000}
C4_1 n4 n5 {6939906281779079/10775956751716035}
R5_0 n5 n6 {8053187174437117/10000000000000000000}
C5_1 n5 n6 {17609467116618380/8053187174437117}
R6_0 n6 n7 {12437561109096673/50000000000000000000}
C6_1 n6 n7 {223413198637438750/12437561109096673}
R7_0 n7 n8 {10320617677315039/100000000000000000000}
C7_1 n7 n8 {2876895179778488400/10320617677315039}
R8_0 n8 n9 {2181867895174539/25000000000000000000}
C8_1 n8 n9 {140382606959355250/167835991936503}
R9_0 n9 n10 {2883052908862317/25000000000000000000}
C9_1 n9 n10 {4630727910162595750/2883052908862317}
R10_0 n10 n11 {3773787711740607/10000000000000000000}
C10_1 n10 n11 {1566681115451811000/1257929237246869}
R11_0 n11 n12 {41967869719604427/100000000000000000000}
C11_1 n11 n12 {119259908410621420000/41967869719604427}
R12_0 n12 n13 {1941477456292207/2500000000000000000}
C12_1 n12 n13 {7565316267316321000/1941477456292207}
R13_0 n13 portn {2941451502891031/2500000000000000000}
C13_1 n13 portn {19196395834033192500/2941451502891031}
.ends NONAGON_POSITIVE_REAL
