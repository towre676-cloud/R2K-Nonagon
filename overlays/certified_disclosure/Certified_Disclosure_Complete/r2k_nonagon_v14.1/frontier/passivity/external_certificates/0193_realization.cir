* Exact decimal-rational passive realization; s=+i*2*pi*f_hz
.subckt NONAGON_POSITIVE_REAL portp portn
R0_0 portp n1 {13868320293062461/1000000000000000000}
L1_0 n1 n2 {9552891255557723/100000000000000000000000}
C2_0 n2 n3 {10000000000000000000/2752951327741923}
R3_0 n3 n4 {15549438708827407/10000000000000000000}
C3_1 n3 n4 {2735023091892717/15549438708827407}
R4_0 n4 n5 {10922414713860017/10000000000000000000}
C4_1 n4 n5 {6939906281779079/10922414713860017}
R5_0 n5 n6 {7752118509143781/10000000000000000000}
C5_1 n5 n6 {17609467116618380/7752118509143781}
R6_0 n6 n7 {676074925845163/2500000000000000000}
C6_1 n6 n7 {22341319863743875/1352149851690326}
R7_0 n7 n8 {38859862982407/390625000000000000}
C7_1 n7 n8 {179805948736155525/621757807718512}
R8_0 n8 n9 {4002343489141061/50000000000000000000}
C8_1 n8 n9 {3649947780943236500/4002343489141061}
R9_0 n9 n10 {13536352308429197/100000000000000000000}
C9_1 n9 n10 {18522911640650383000/13536352308429197}
R10_0 n10 n11 {3498109218530519/10000000000000000000}
C10_1 n10 n11 {4700043346355433000/3498109218530519}
R11_0 n11 n12 {9348432644373561/20000000000000000000}
C11_1 n11 n12 {23851981682124284000/9348432644373561}
R12_0 n12 n13 {1319010115838479/2000000000000000000}
C12_1 n12 n13 {6052253013853056800/1319010115838479}
R13_0 n13 portn {14383442185987663/10000000000000000000}
C13_1 n13 portn {76785583336132770000/14383442185987663}
.ends NONAGON_POSITIVE_REAL
