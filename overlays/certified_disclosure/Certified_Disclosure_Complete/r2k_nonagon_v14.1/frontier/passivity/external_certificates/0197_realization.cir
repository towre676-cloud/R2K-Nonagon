* Exact decimal-rational passive realization; s=+i*2*pi*f_hz
.subckt NONAGON_POSITIVE_REAL portp portn
R0_0 portp n1 {868043128339367/62500000000000000}
L1_0 n1 n2 {2359711556481299/25000000000000000000000}
C2_0 n2 n3 {100000000000000000000/28913720187304613}
R3_0 n3 n4 {15823524206110343/10000000000000000000}
C3_1 n3 n4 {2735023091892717/15823524206110343}
R4_0 n4 n5 {2609449431107807/2500000000000000000}
C4_1 n4 n5 {6939906281779079/10437797724431228}
R5_0 n5 n6 {308298915688773/400000000000000000}
C5_1 n5 n6 {3521893423323676/1541494578443865}
R6_0 n6 n7 {3380516176481173/12500000000000000000}
C6_1 n6 n7 {111706599318719375/6761032352962346}
R7_0 n7 n8 {1297344692065283/12500000000000000000}
C7_1 n7 n8 {359611897472311050/1297344692065283}
R8_0 n8 n9 {3804880178070807/50000000000000000000}
C8_1 n8 n9 {3649947780943236500/3804880178070807}
R9_0 n9 n10 {6913713967573243/50000000000000000000}
C9_1 n9 n10 {9261455820325191500/6913713967573243}
R10_0 n10 n11 {4474283338594043/12500000000000000000}
C10_1 n10 n11 {5875054182944291250/4474283338594043}
R11_0 n11 n12 {4440128155240651/10000000000000000000}
C11_1 n11 n12 {11925990841062142000/4440128155240651}
R12_0 n12 n13 {3670059623953231/5000000000000000000}
C12_1 n12 n13 {15130632534632642000/3670059623953231}
R13_0 n13 portn {30721443576287/25000000000000000}
C13_1 n13 portn {191963958340331925/30721443576287}
.ends NONAGON_POSITIVE_REAL
