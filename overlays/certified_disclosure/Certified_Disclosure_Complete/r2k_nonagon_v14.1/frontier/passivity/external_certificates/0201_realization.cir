* Exact decimal-rational passive realization; s=+i*2*pi*f_hz
.subckt NONAGON_POSITIVE_REAL portp portn
R0_0 portp n1 {6849066097068819/500000000000000000}
L1_0 n1 n2 {9452562727793277/100000000000000000000000}
C2_0 n2 n3 {5000000000000000000/1334564703568019}
R3_0 n3 n4 {4124378418818267/2500000000000000000}
C3_1 n3 n4 {2735023091892717/16497513675273068}
R4_0 n4 n5 {9171296971526433/10000000000000000000}
C4_1 n4 n5 {6939906281779079/9171296971526433}
R5_0 n5 n6 {528967764964047/625000000000000000}
C5_1 n5 n6 {4402366779154595/2115871059856188}
R6_0 n6 n7 {8788067490055591/50000000000000000000}
C6_1 n6 n7 {223413198637438750/8788067490055591}
R7_0 n7 n8 {4678657531319213/100000000000000000000}
C7_1 n7 n8 {1133786888492665700/4678657531319213}
R8_0 n8 n9 {7742744414716427/100000000000000000000}
C8_1 n8 n9 {2876895179778488400/7742744414716427}
R9_0 n9 n10 {884190542619591/10000000000000000000}
C9_1 n9 n10 {729989556188647300/884190542619591}
R10_0 n10 n11 {283428461075851/2000000000000000000}
C10_1 n10 n11 {370458232813007660/283428461075851}
R11_0 n11 n12 {1709133576516333/5000000000000000000}
C11_1 n11 n12 {261113519241968500/189903730724037}
R12_0 n12 n13 {11825153365588881/25000000000000000000}
C12_1 n12 n13 {29814977102655355000/11825153365588881}
R13_0 n13 n14 {1287937457632471/2000000000000000000}
C13_1 n13 n14 {6052253013853056800/1287937457632471}
R14_0 n14 portn {15021478783885543/10000000000000000000}
C14_1 n14 portn {76785583336132770000/15021478783885543}
.ends NONAGON_POSITIVE_REAL
