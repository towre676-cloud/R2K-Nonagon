* Exact decimal-rational passive realization; s=+i*2*pi*f_hz
.subckt NONAGON_POSITIVE_REAL portp portn
R0_0 portp n1 {1370524420214717/100000000000000000}
L1_0 n1 n2 {4717851621266183/50000000000000000000000}
C2_0 n2 n3 {400000000000000000/116835810158527}
R3_0 n3 n4 {4152447559997899/2500000000000000000}
C3_1 n3 n4 {2735023091892717/16609790239991596}
R4_0 n4 n5 {4029528031274491/5000000000000000000}
C4_1 n4 n5 {6939906281779079/8059056062548982}
R5_0 n5 n6 {578295049660507/500000000000000000}
C5_1 n5 n6 {880473355830919/578295049660507}
R6_0 n6 n7 {3913353040572801/100000000000000000000}
C6_1 n6 n7 {45665002853626800/62116714929727}
R7_0 n7 n8 {177423314806699/1000000000000000000}
C7_1 n7 n8 {5615304278374210/13647947292823}
R8_0 n8 n9 {51895202815262953/1000000000000000000000}
C8_1 n8 n9 {185229116406503830000/51895202815262953}
R9_0 n9 n10 {4330016312677787/10000000000000000000}
C9_1 n9 n10 {4700043346355433000/4330016312677787}
R10_0 n10 n11 {17772746390215473/50000000000000000000}
C10_1 n10 n11 {59629954205310710000/17772746390215473}
R11_0 n11 n12 {112014190073501/125000000000000000}
C11_1 n11 n12 {378265813365816050/112014190073501}
R12_0 n12 portn {5003755439995591/5000000000000000000}
C12_1 n12 portn {38392791668066385000/5003755439995591}
.ends NONAGON_POSITIVE_REAL
