* Exact decimal-rational passive realization; s=+i*2*pi*f_hz
.subckt NONAGON_POSITIVE_REAL portp portn
R0_0 portp n1 {1734515697853391/125000000000000000}
L1_0 n1 n2 {1181926081474609/12500000000000000000000}
C2_0 n2 n3 {100000000000000000000/27509110524035933}
R3_0 n3 n4 {15139987388406997/10000000000000000000}
C3_1 n3 n4 {2735023091892717/15139987388406997}
R4_0 n4 n5 {1061208703429141/1000000000000000000}
C4_1 n4 n5 {6939906281779079/10612087034291410}
R5_0 n5 n6 {289500362633911/400000000000000000}
C5_1 n5 n6 {3521893423323676/1447501813169555}
R6_0 n6 n7 {4873743847071909/20000000000000000000}
C6_1 n6 n7 {89365279454975500/4873743847071909}
R7_0 n7 n8 {9881102373658963/100000000000000000000}
C7_1 n7 n8 {2876895179778488400/9881102373658963}
R8_0 n8 n9 {8401118222747151/100000000000000000000}
C8_1 n8 n9 {7299895561886473000/8401118222747151}
R9_0 n9 n10 {1688294480742133/12500000000000000000}
C9_1 n9 n10 {2315363955081297875/1688294480742133}
R10_0 n10 n11 {1756792001882853/5000000000000000000}
C10_1 n10 n11 {261113519241968500/195199111320317}
R11_0 n11 n12 {1141428405705803/2500000000000000000}
C11_1 n11 n12 {2981497710265535500/1141428405705803}
R12_0 n12 n13 {3515007565749141/5000000000000000000}
C12_1 n12 n13 {15130632534632642000/3515007565749141}
R13_0 n13 portn {3371558983036861/2500000000000000000}
C13_1 n13 portn {19196395834033192500/3371558983036861}
.ends NONAGON_POSITIVE_REAL
