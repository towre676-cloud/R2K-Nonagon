* Exact decimal-rational passive realization; s=+i*2*pi*f_hz
.subckt NONAGON_POSITIVE_REAL portp portn
R0_0 portp n1 {3471031151990503/250000000000000000}
L1_0 n1 n2 {4722603119197397/50000000000000000000000}
C2_0 n2 n3 {10000000000000000000/2951729360680031}
R3_0 n3 n4 {3809671827943611/2500000000000000000}
C3_1 n3 n4 {911674363964239/5079562437258148}
R4_0 n4 n5 {4761359175097893/5000000000000000000}
C4_1 n4 n5 {6939906281779079/9522718350195786}
R5_0 n5 n6 {10601103325405547/10000000000000000000}
C5_1 n5 n6 {17609467116618380/10601103325405547}
R6_0 n6 n7 {5034640649703437/100000000000000000000}
C6_1 n6 n7 {2876895179778488400/5034640649703437}
R7_0 n7 n8 {8905993914294161/50000000000000000000}
C7_1 n7 n8 {3649947780943236500/8905993914294161}
R8_0 n8 n9 {4587144461617129/100000000000000000000}
C8_1 n8 n9 {18522911640650383000/4587144461617129}
R9_0 n9 n10 {5495098838628467/12500000000000000000}
C9_1 n9 n10 {5875054182944291250/5495098838628467}
R10_0 n10 n11 {42136544029899/125000000000000000}
C10_1 n10 n11 {149074885513276775/42136544029899}
R11_0 n11 n12 {939562385342911/1000000000000000000}
C11_1 n11 n12 {3026126506926528400/939562385342911}
R12_0 n12 portn {4587986761218183/5000000000000000000}
C12_1 n12 portn {12797597222688795000/1529328920406061}
.ends NONAGON_POSITIVE_REAL
