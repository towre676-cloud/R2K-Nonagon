* Exact decimal-rational passive realization; s=+i*2*pi*f_hz
.subckt NONAGON_POSITIVE_REAL portp portn
R0_0 portp n1 {174946541836043/12500000000000000}
L1_0 n1 n2 {9245054066383449/100000000000000000000000}
R2_0 n2 n3 {14147161342992387/10000000000000000000}
C2_1 n2 n3 {911674363964239/4715720447664129}
R3_0 n3 n4 {13354161498415169/10000000000000000000}
C3_1 n3 n4 {6939906281779079/13354161498415169}
R4_0 n4 n5 {6953206558555961/10000000000000000000}
C4_1 n4 n5 {17609467116618380/6953206558555961}
R5_0 n5 n6 {501381323782023/1250000000000000000}
C5_1 n5 n6 {22341319863743875/2005525295128092}
R6_0 n6 n7 {7245524868302309/250000000000000000000}
C6_1 n6 n7 {2834467221231664250/7245524868302309}
R7_0 n7 n8 {12717464535864033/100000000000000000000}
C7_1 n7 n8 {958965059926162800/4239154845288011}
R8_0 n8 n9 {10603726841356133/100000000000000000000}
C8_1 n8 n9 {7299895561886473000/10603726841356133}
R9_0 n9 n10 {13165704702363537/100000000000000000000}
C9_1 n9 n10 {18522911640650383000/13165704702363537}
R10_0 n10 n11 {2426873256811001/6250000000000000000}
C10_1 n10 n11 {2937527091472145625/2426873256811001}
R11_0 n11 n12 {2719191676761723/5000000000000000000}
C11_1 n11 n12 {5962995420531071000/2719191676761723}
R12_0 n12 n13 {2196024902570327/500000000000000000}
C12_1 n12 n13 {3839279166806638500/2196024902570327}
R13_0 n13 portn {9488292366373621/10000000000000000000}
C13_1 n13 portn {194837386830151900000/9488292366373621}
.ends NONAGON_POSITIVE_REAL
