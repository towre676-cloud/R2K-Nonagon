* Exact decimal-rational passive realization; s=+i*2*pi*f_hz
.subckt NONAGON_POSITIVE_REAL portp portn
R0_0 portp n1 {87045760691327/6250000000000000}
L1_0 n1 n2 {9303548552385679/100000000000000000000000}
R2_0 n2 n3 {3247493276827951/2000000000000000000}
C2_1 n2 n3 {2735023091892717/16237466384139755}
R3_0 n3 n4 {10406609675375751/10000000000000000000}
C3_1 n3 n4 {6939906281779079/10406609675375751}
R4_0 n4 n5 {4515634885078973/5000000000000000000}
C4_1 n4 n5 {8804733558309190/4515634885078973}
R5_0 n5 n6 {45580309609331843/100000000000000000000}
C5_1 n5 n6 {446826397274877500/45580309609331843}
R6_0 n6 n7 {4903912016289163/25000000000000000000}
C6_1 n6 n7 {1824973890471618250/4903912016289163}
R7_0 n7 n8 {2699826647942459/25000000000000000000}
C7_1 n7 n8 {4630727910162595750/2699826647942459}
R8_0 n8 n9 {1646669602730187/5000000000000000000}
C8_1 n8 n9 {261113519241968500/182963289192243}
R9_0 n9 n10 {6541606573441071/10000000000000000000}
C9_1 n9 n10 {11925990841062142000/6541606573441071}
R10_0 n10 n11 {7746062438062827/2000000000000000000}
C10_1 n10 n11 {1706346296358506000/860673604229203}
R11_0 n11 portn {9362846640391649/5000000000000000000}
C11_1 n11 portn {97418693415075950000/9362846640391649}
.ends NONAGON_POSITIVE_REAL
