* Exact decimal-rational passive realization; s=+i*2*pi*f_hz
.subckt NONAGON_POSITIVE_REAL portp portn
R0_0 portp n1 {13608265868218233/1000000000000000000}
L1_0 n1 n2 {4631258095953661/50000000000000000000000}
R2_0 n2 n3 {315512073063753/200000000000000000}
C2_1 n2 n3 {911674363964239/5258534551062550}
R3_0 n3 n4 {12228704694719377/10000000000000000000}
C3_1 n3 n4 {6939906281779079/12228704694719377}
R4_0 n4 n5 {2073706125547639/2500000000000000000}
C4_1 n4 n5 {4402366779154595/2073706125547639}
R5_0 n5 n6 {435615971073029/1250000000000000000}
C5_1 n5 n6 {22341319863743875/1742463884292116}
R6_0 n6 n7 {5126539187171807/100000000000000000000}
C6_1 n6 n7 {1133786888492665700/5126539187171807}
R7_0 n7 n8 {5989810091843857/50000000000000000000}
C7_1 n7 n8 {1438447589889244200/5989810091843857}
R8_0 n8 n9 {3132704988387287/25000000000000000000}
C8_1 n8 n9 {1824973890471618250/3132704988387287}
R9_0 n9 n10 {5513590710054773/50000000000000000000}
C9_1 n9 n10 {9261455820325191500/5513590710054773}
R10_0 n10 n11 {19698183055614097/50000000000000000000}
C10_1 n10 n11 {23500216731777165000/19698183055614097}
R11_0 n11 n12 {5513169185997201/10000000000000000000}
C11_1 n11 n12 {62439742623362000/28864760136111}
R12_0 n12 n13 {2011397196743599/500000000000000000}
C12_1 n12 n13 {3839279166806638500/2011397196743599}
R13_0 n13 portn {2214273301736287/1250000000000000000}
C13_1 n13 portn {24354673353768987500/2214273301736287}
.ends NONAGON_POSITIVE_REAL
