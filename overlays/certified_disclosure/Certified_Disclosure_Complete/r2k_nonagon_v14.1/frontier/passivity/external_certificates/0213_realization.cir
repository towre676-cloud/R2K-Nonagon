* Exact decimal-rational passive realization; s=+i*2*pi*f_hz
.subckt NONAGON_POSITIVE_REAL portp portn
R0_0 portp n1 {1356839579057519/100000000000000000}
L1_0 n1 n2 {9305401089964857/100000000000000000000000}
R2_0 n2 n3 {3469038572032541/2000000000000000000}
C2_1 n2 n3 {2735023091892717/17345192860162705}
R3_0 n3 n4 {623835440942733/625000000000000000}
C3_1 n3 n4 {6939906281779079/9981367055083728}
R4_0 n4 n5 {9881089955920317/10000000000000000000}
C4_1 n4 n5 {17609467116618380/9881089955920317}
R5_0 n5 n6 {7176087401795651/25000000000000000000}
C5_1 n5 n6 {111706599318719375/7176087401795651}
R6_0 n6 n7 {7728778411954033/100000000000000000000}
C6_1 n6 n7 {1133786888492665700/7728778411954033}
R7_0 n7 n8 {9937456231444363/100000000000000000000}
C7_1 n7 n8 {2876895179778488400/9937456231444363}
R8_0 n8 n9 {11307768144539337/100000000000000000000}
C8_1 n8 n9 {7299895561886473000/11307768144539337}
R9_0 n9 n10 {1604092279564643/10000000000000000000}
C9_1 n9 n10 {1852291164065038300/1604092279564643}
R10_0 n10 n11 {309752646271383/1000000000000000000}
C10_1 n10 n11 {156668111545181100/103250882090461}
R11_0 n11 n12 {51406726668309/80000000000000000}
C11_1 n11 n12 {95407926728497136/51406726668309}
R12_0 n12 n13 {3817310141205973/1000000000000000000}
C12_1 n12 n13 {7678558333613277000/3817310141205973}
R13_0 n13 portn {10255915411873/5000000000000000}
C13_1 n13 portn {97418693415075950/10255915411873}
.ends NONAGON_POSITIVE_REAL
