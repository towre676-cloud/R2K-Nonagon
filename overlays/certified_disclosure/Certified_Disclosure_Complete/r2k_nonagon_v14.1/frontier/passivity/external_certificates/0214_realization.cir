* Exact decimal-rational passive realization; s=+i*2*pi*f_hz
.subckt NONAGON_POSITIVE_REAL portp portn
R0_0 portp n1 {848388359243661/62500000000000000}
L1_0 n1 n2 {9280724373032633/100000000000000000000000}
R2_0 n2 n3 {875626645139473/500000000000000000}
C2_1 n2 n3 {2735023091892717/17512532902789460}
R3_0 n3 n4 {8567651804288149/10000000000000000000}
C3_1 n3 n4 {6939906281779079/8567651804288149}
R4_0 n4 n5 {784634729488883/625000000000000000}
C4_1 n4 n5 {4402366779154595/3138538917955532}
R5_0 n5 n6 {1385203970258903/5000000000000000000}
C5_1 n5 n6 {22341319863743875/1385203970258903}
R6_0 n6 n7 {19753691257219067/100000000000000000000}
C6_1 n6 n7 {7299895561886473000/19753691257219067}
R7_0 n7 n8 {4742103335125419/50000000000000000000}
C7_1 n7 n8 {9261455820325191500/4742103335125419}
R8_0 n8 n9 {1795760584689571/5000000000000000000}
C8_1 n8 n9 {2350021673177716500/1795760584689571}
R9_0 n9 n10 {6140229147417717/10000000000000000000}
C9_1 n9 n10 {11925990841062142000/6140229147417717}
R10_0 n10 n11 {1150303288427123/312500000000000000}
C10_1 n10 n11 {4799098958508298125/2300606576854246}
R11_0 n11 portn {2422384057741617/1000000000000000000}
C11_1 n11 portn {19483738683015190000/2422384057741617}
.ends NONAGON_POSITIVE_REAL
