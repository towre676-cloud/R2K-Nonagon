Nonagon external DC circuit random_01_n4 heldout_0
.options reltol=1e-12 abstol=1e-15 vntol=1e-12 gmin=1e-18
Iinput 0 n1 DC 0.0001
Redge_1_2 n1 n2 1000
Redge_1_3 n1 n3 500
Rground_1 n1 0 666.66666666666663
Redge_2_4 n2 n4 333.33333333333331
Rground_2 n2 0 1000
Rground_3 n3 0 666.66666666666663
Rground_4 n4 0 800
Rload_1 n1 0 3000
Rload_4 n4 0 2500
.control
set numdgt=17
op
print v(n1) v(n2) v(n3) v(n4)
quit
.endc
.end
