Nonagon external DC circuit random_02_n5 heldout_2
.options reltol=1e-12 abstol=1e-15 vntol=1e-12 gmin=1e-18
Iinput 0 n1 DC 0.0001
Redge_1_2 n1 n2 1000
Rground_1 n1 0 500
Redge_2_3 n2 n3 250
Redge_2_4 n2 n4 400
Rground_2 n2 0 1000
Redge_3_4 n3 n4 400
Rground_3 n3 0 1000
Redge_4_5 n4 n5 1000
Rground_4 n4 0 1000
Rground_5 n5 0 3000
Rload_1 n1 0 13000
Rload_5 n5 0 1571.4285714285713
.control
set numdgt=17
op
print v(n1) v(n2) v(n3) v(n4) v(n5)
quit
.endc
.end
