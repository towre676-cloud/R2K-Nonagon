Nonagon external DC circuit random_04_n7 pair_2_3
.options reltol=1e-12 abstol=1e-15 vntol=1e-12 gmin=1e-18
Iinput 0 n1 DC 0.0001
Redge_1_2 n1 n2 125
Redge_1_3 n1 n3 666.66666666666663
Redge_1_4 n1 n4 500
Rground_1 n1 0 1000
Redge_2_3 n2 n3 250
Redge_2_4 n2 n4 1000
Redge_2_5 n2 n5 333.33333333333331
Redge_3_5 n3 n5 375
Rground_3 n3 0 400
Redge_4_5 n4 n5 1333.3333333333333
Redge_4_6 n4 n6 2000
Redge_4_7 n4 n7 600
Rground_4 n4 0 1000
Redge_5_6 n5 n6 2000
Redge_6_7 n6 n7 1000
Rground_6 n6 0 1000
Rground_7 n7 0 333.33333333333331
Rload_3 n3 0 1000
Rload_4 n4 0 1000
.control
set numdgt=17
op
print v(n1) v(n2) v(n3) v(n4) v(n5) v(n6) v(n7)
quit
.endc
.end
