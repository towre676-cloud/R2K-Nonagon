Nonagon external DC circuit v7_path single_2_b
.options reltol=1e-12 abstol=1e-15 vntol=1e-12 gmin=1e-18
Iinput 0 n1 DC 0.0001
Redge_1_2 n1 n2 1000
Rground_1 n1 0 333.33333333333331
Redge_2_3 n2 n3 1000
Rground_2 n2 0 1000
Rground_3 n3 0 1000
Rload_3 n3 0 500
.control
set numdgt=17
op
print v(n1) v(n2) v(n3)
quit
.endc
.end
