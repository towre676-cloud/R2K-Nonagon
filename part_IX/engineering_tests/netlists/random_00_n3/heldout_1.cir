Nonagon external DC circuit random_00_n3 heldout_1
.options reltol=1e-12 abstol=1e-15 vntol=1e-12 gmin=1e-18
Iinput 0 n1 DC 0.0001
Redge_1_2 n1 n2 250
Redge_1_3 n1 n3 833.33333333333337
Rground_1 n1 0 1000
Rground_2 n2 0 750
Rground_3 n3 0 500
Rload_2 n2 0 2333.3333333333335
Rload_3 n3 0 2200
.control
set numdgt=17
op
print v(n1) v(n2) v(n3)
quit
.endc
.end
