Nonagon external DC circuit random_03_n6 pair_2_4
.options reltol=1e-12 abstol=1e-15 vntol=1e-12 gmin=1e-18
Iinput 0 n1 DC 0.0001
Redge_1_2 n1 n2 285.71428571428572
Redge_1_5 n1 n5 1000
Redge_1_6 n1 n6 750
Rground_1 n1 0 333.33333333333331
Redge_2_3 n2 n3 500
Redge_2_4 n2 n4 1250
Redge_3_4 n3 n4 285.71428571428572
Redge_3_5 n3 n5 571.42857142857144
Redge_4_6 n4 n6 1000
Rground_5 n5 0 285.71428571428572
Rload_3 n3 0 1000
Rload_5 n5 0 1000
.control
set numdgt=17
op
print v(n1) v(n2) v(n3) v(n4) v(n5) v(n6)
quit
.endc
.end
