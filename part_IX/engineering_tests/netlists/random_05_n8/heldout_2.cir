Nonagon external DC circuit random_05_n8 heldout_2
.options reltol=1e-12 abstol=1e-15 vntol=1e-12 gmin=1e-18
Iinput 0 n1 DC 0.0001
Redge_1_2 n1 n2 1666.6666666666667
Redge_1_3 n1 n3 1250
Redge_1_4 n1 n4 750
Redge_1_5 n1 n5 166.66666666666666
Redge_1_6 n1 n6 500
Redge_1_8 n1 n8 1000
Rground_1 n1 0 750
Redge_2_3 n2 n3 625
Redge_2_5 n2 n5 250
Redge_2_6 n2 n6 800
Redge_3_8 n3 n8 714.28571428571433
Rground_3 n3 0 800
Redge_4_5 n4 n5 833.33333333333337
Redge_4_7 n4 n7 500
Redge_4_8 n4 n8 400
Rground_4 n4 0 250
Rground_5 n5 0 1500
Rload_1 n1 0 13000
Rload_8 n8 0 1571.4285714285713
.control
set numdgt=17
op
print v(n1) v(n2) v(n3) v(n4) v(n5) v(n6) v(n7) v(n8)
quit
.endc
.end
