Nonagon external DC circuit random_07_n4 single_3_b
.options reltol=1e-12 abstol=1e-15 vntol=1e-12 gmin=1e-18
Iinput 0 n1 DC 0.0001
Redge_1_2 n1 n2 1000
Redge_1_3 n1 n3 833.33333333333337
Redge_1_4 n1 n4 400
Rground_1 n1 0 500
Rground_2 n2 0 750
Rground_4 n4 0 1250
Rload_4 n4 0 500
.control
set numdgt=17
op
print v(n1) v(n2) v(n3) v(n4)
quit
.endc
.end
