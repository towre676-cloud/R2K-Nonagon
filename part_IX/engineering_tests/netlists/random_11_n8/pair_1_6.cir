Nonagon external DC circuit random_11_n8 pair_1_6
.options reltol=1e-12 abstol=1e-15 vntol=1e-12 gmin=1e-18
Iinput 0 n1 DC 0.0001
Redge_1_2 n1 n2 375
Redge_1_3 n1 n3 200
Redge_1_5 n1 n5 1666.6666666666667
Redge_1_6 n1 n6 666.66666666666663
Redge_1_7 n1 n7 1000
Redge_1_8 n1 n8 1000
Rground_1 n1 0 1000
Redge_2_6 n2 n6 5000
Redge_3_4 n3 n4 500
Redge_3_6 n3 n6 714.28571428571433
Redge_3_8 n3 n8 1000
Rground_3 n3 0 666.66666666666663
Redge_4_7 n4 n7 250
Rground_4 n4 0 166.66666666666666
Redge_5_6 n5 n6 1250
Redge_5_8 n5 n8 800
Rground_5 n5 0 2000
Rground_8 n8 0 1500
Rload_2 n2 0 1000
Rload_7 n7 0 1000
.control
set numdgt=17
op
print v(n1) v(n2) v(n3) v(n4) v(n5) v(n6) v(n7) v(n8)
quit
.endc
.end
